* CLK-AOCV MC chain A TT sample 1
.control
pre_osdi /w/osdi/bsimcmg23.osdi
set noaskquit
run
wrdata /w/run/A_TT/s0001.dat v(n1) v(o1) v(n2) v(o2) v(n3) v(o3) v(n4) v(o4) v(n5) v(o5) v(n6) v(o6) v(n7)
quit
.endc
.options klu
.save v(n1) v(o1) v(n2) v(o2) v(n3) v(o3) v(n4) v(o4) v(n5) v(o5) v(n6) v(o6) v(n7)
.temp 25
.include /w/lib/TT/models.sp
.include /w/lib/TT/cells.sp
.subckt MCBUF VSS VDD A Y d0=0 d1=0 d2=0 d3=0 d4=0 d5=0 d6=0 d7=0 d8=0 d9=0 d10=0 d11=0 d12=0 d13=0 d14=0 d15=0 d16=0 d17=0 d18=0 d19=0 d20=0 d21=0 d22=0 d23=0 d24=0 d25=0 d26=0 d27=0 d28=0 d29=0 d30=0 d31=0 d32=0 d33=0 d34=0 d35=0 d36=0 d37=0 d38=0 d39=0 d40=0 d41=0 d42=0 d43=0 d44=0 d45=0 d46=0 d47=0 d48=0 d49=0 d50=0 d51=0 d52=0 d53=0 d54=0 d55=0
*
* VSS VSS
* VDD VDD
* A A
* Y Y
*
*

N0 N_M0_d N_M0_g VSS VSS nmos_rvt L=2e-08 nfin=3 delvtrand={d0}
N1 N_M1_d N_M1_g VSS VSS nmos_rvt L=2e-08 nfin=3 delvtrand={d1}
N2 N_M2_d N_M2_g VSS VSS nmos_rvt L=2e-08 nfin=3 delvtrand={d2}
N3 N_M3_d N_M3_g VSS VSS nmos_rvt L=2e-08 nfin=3 delvtrand={d3}
N4 N_M4_d N_M4_g VSS VSS nmos_rvt L=2e-08 nfin=3 delvtrand={d4}
N5 N_M5_d N_M5_g VSS VSS nmos_rvt L=2e-08 nfin=3 delvtrand={d5}
N6 N_M6_d N_M6_g VSS VSS nmos_rvt L=2e-08 nfin=3 delvtrand={d6}
N7 N_M7_d N_M7_g VSS VSS nmos_rvt L=2e-08 nfin=3 delvtrand={d7}
N8 N_M8_d N_M8_g VSS VSS nmos_rvt L=2e-08 nfin=3 delvtrand={d8}
N9 N_M9_d N_M9_g VSS VSS nmos_rvt L=2e-08 nfin=3 delvtrand={d9}
N10 N_M10_d N_M10_g VSS VSS nmos_rvt L=2e-08 nfin=3 delvtrand={d10}
N11 N_M11_d N_M11_g VSS VSS nmos_rvt L=2e-08 nfin=3 delvtrand={d11}
N12 N_M12_d N_M12_g VSS VSS nmos_rvt L=2e-08 nfin=3 delvtrand={d12}
N13 N_M13_d N_M13_g VSS VSS nmos_rvt L=2e-08 nfin=3 delvtrand={d13}
N14 N_M14_d N_M14_g VSS VSS nmos_rvt L=2e-08 nfin=3 delvtrand={d14}
N15 N_M15_d N_M15_g VSS VSS nmos_rvt L=2e-08 nfin=3 delvtrand={d15}
N16 N_M16_d N_M16_g VSS VSS nmos_rvt L=2e-08 nfin=3 delvtrand={d16}
N17 N_M17_d N_M17_g VSS VSS nmos_rvt L=2e-08 nfin=3 delvtrand={d17}
N18 N_M18_d N_M18_g VSS VSS nmos_rvt L=2e-08 nfin=3 delvtrand={d18}
N19 N_M19_d N_M19_g VSS VSS nmos_rvt L=2e-08 nfin=3 delvtrand={d19}
N20 N_M20_d N_M20_g VSS VSS nmos_rvt L=2e-08 nfin=3 delvtrand={d20}
N21 N_M21_d N_M21_g VSS VSS nmos_rvt L=2e-08 nfin=3 delvtrand={d21}
N22 N_M22_d N_M22_g VSS VSS nmos_rvt L=2e-08 nfin=3 delvtrand={d22}
N23 N_M23_d N_M23_g VSS VSS nmos_rvt L=2e-08 nfin=3 delvtrand={d23}
N24 N_M24_d N_M24_g VSS VSS nmos_rvt L=2e-08 nfin=3 delvtrand={d24}
N25 N_M25_d N_M25_g VSS VSS nmos_rvt L=2e-08 nfin=3 delvtrand={d25}
N26 N_M26_d N_M26_g VSS VSS nmos_rvt L=2e-08 nfin=3 delvtrand={d26}
N27 N_M27_d N_M27_g VSS VSS nmos_rvt L=2e-08 nfin=3 delvtrand={d27}
N28 N_M28_d N_M28_g VDD VDD pmos_rvt L=2e-08 nfin=3 delvtrand={d28}
N29 N_M29_d N_M29_g VDD VDD pmos_rvt L=2e-08 nfin=3 delvtrand={d29}
N30 N_M30_d N_M30_g VDD VDD pmos_rvt L=2e-08 nfin=3 delvtrand={d30}
N31 N_M31_d N_M31_g VDD VDD pmos_rvt L=2e-08 nfin=3 delvtrand={d31}
N32 N_M32_d N_M32_g VDD VDD pmos_rvt L=2e-08 nfin=3 delvtrand={d32}
N33 N_M33_d N_M33_g VDD VDD pmos_rvt L=2e-08 nfin=3 delvtrand={d33}
N34 N_M34_d N_M34_g VDD VDD pmos_rvt L=2e-08 nfin=3 delvtrand={d34}
N35 N_M35_d N_M35_g VDD VDD pmos_rvt L=2e-08 nfin=3 delvtrand={d35}
N36 N_M36_d N_M36_g VDD VDD pmos_rvt L=2e-08 nfin=3 delvtrand={d36}
N37 N_M37_d N_M37_g VDD VDD pmos_rvt L=2e-08 nfin=3 delvtrand={d37}
N38 N_M38_d N_M38_g VDD VDD pmos_rvt L=2e-08 nfin=3 delvtrand={d38}
N39 N_M39_d N_M39_g VDD VDD pmos_rvt L=2e-08 nfin=3 delvtrand={d39}
N40 N_M40_d N_M40_g VDD VDD pmos_rvt L=2e-08 nfin=3 delvtrand={d40}
N41 N_M41_d N_M41_g VDD VDD pmos_rvt L=2e-08 nfin=3 delvtrand={d41}
N42 N_M42_d N_M42_g VDD VDD pmos_rvt L=2e-08 nfin=3 delvtrand={d42}
N43 N_M43_d N_M43_g VDD VDD pmos_rvt L=2e-08 nfin=3 delvtrand={d43}
N44 N_M44_d N_M44_g VDD VDD pmos_rvt L=2e-08 nfin=3 delvtrand={d44}
N45 N_M45_d N_M45_g VDD VDD pmos_rvt L=2e-08 nfin=3 delvtrand={d45}
N46 N_M46_d N_M46_g VDD VDD pmos_rvt L=2e-08 nfin=3 delvtrand={d46}
N47 N_M47_d N_M47_g VDD VDD pmos_rvt L=2e-08 nfin=3 delvtrand={d47}
N48 N_M48_d N_M48_g VDD VDD pmos_rvt L=2e-08 nfin=3 delvtrand={d48}
N49 N_M49_d N_M49_g VDD VDD pmos_rvt L=2e-08 nfin=3 delvtrand={d49}
N50 N_M50_d N_M50_g VDD VDD pmos_rvt L=2e-08 nfin=3 delvtrand={d50}
N51 N_M51_d N_M51_g VDD VDD pmos_rvt L=2e-08 nfin=3 delvtrand={d51}
N52 N_M52_d N_M52_g VDD VDD pmos_rvt L=2e-08 nfin=3 delvtrand={d52}
N53 N_M53_d N_M53_g VDD VDD pmos_rvt L=2e-08 nfin=3 delvtrand={d53}
N54 N_M54_d N_M54_g VDD VDD pmos_rvt L=2e-08 nfin=3 delvtrand={d54}
N55 N_M55_d N_M55_g VDD VDD pmos_rvt L=2e-08 nfin=3 delvtrand={d55}

* .include "BUFx24_ASAP7_75t_R.pex.sp.pxi"

* Start of included file BUFx24_ASAP7_75t_R.pex.sp.pxi
x_PM_BUFx24_ASAP7_75t_R%A vss A N_M0_g N_M28_g N_M1_g N_M29_g N_M2_g N_M30_g
+ N_M3_g N_M31_g N_A_6 N_A_7 N_A_12 N_A_5 N_A_3 N_A_4 N_A_1
+ PM_BUFx24_ASAP7_75t_R%A
x_PM_BUFx24_ASAP7_75t_R%4 vss N_M10_g N_M38_g N_M9_g N_M37_g N_M8_g N_M36_g
+ N_M7_g N_M35_g N_M6_g N_M34_g N_M5_g N_M33_g N_M4_g N_M32_g N_M11_g N_M39_g
+ N_M12_g N_M40_g N_M13_g N_M41_g N_M14_g N_M42_g N_M15_g N_M43_g N_M16_g
+ N_M44_g N_M17_g N_M45_g N_M18_g N_M46_g N_M19_g N_M47_g N_M20_g N_M48_g
+ N_M21_g N_M49_g N_M22_g N_M50_g N_M23_g N_M51_g N_M24_g N_M52_g N_M25_g
+ N_M53_g N_M26_g N_M54_g N_M27_g N_M55_g N_M0_d N_M1_d N_M2_d N_M3_d N_M28_d
+ N_M29_d N_M30_d N_M31_d N_4_1 N_4_67 N_4_73 N_4_26 N_4_27 N_4_71 N_4_72
+ N_4_70 N_4_69 N_4_65 N_4_63 N_4_64 N_4_62 N_4_28 N_4_29 N_4_38 N_4_40 N_4_42
+ N_4_44 N_4_46 N_4_48 N_4_50 N_4_52 N_4_54 N_4_56 N_4_58 N_4_60 N_4_66 N_4_68
+ N_4_61 N_4_41 N_4_43 N_4_45 N_4_47 N_4_49 N_4_51 N_4_53 N_4_55 N_4_57 N_4_59
+ N_4_39 PM_BUFx24_ASAP7_75t_R%4
cc_1 N_4_1 N_A_6 8.89152e-20
cc_2 N_4_67 N_A_6 0.000194401f
cc_3 N_4_73 N_A_6 0.000235871f
cc_4 N_4_26 N_A_6 0.000678135f
cc_5 N_4_27 N_A_6 0.000270868f
cc_6 N_4_71 N_A_6 0.00039413f
cc_7 N_4_72 N_A_6 0.00039413f
cc_8 N_4_70 N_A_6 0.000956969f
cc_9 N_4_69 N_A_6 0.000479525f
cc_10 N_4_69 N_A_7 0.00048479f
cc_11 N_4_26 N_A_12 0.000682159f
cc_12 N_4_69 N_A_5 0.000715928f
cc_13 N_4_70 N_A_5 0.000715928f
cc_14 N_4_65 N_A_5 0.0576592f
cc_15 N_4_63 N_A_6 0.000853152f
cc_16 N_4_64 N_A_3 0.0304771f
cc_17 N_4_62 N_A_4 0.0304946f
cc_18 N_4_28 N_A_5 0.00161271f
cc_19 N_4_29 N_A_5 0.00161271f
cc_20 N_4_38 N_A_6 0.00175223f
cc_21 N_4_26 N_A_3 0.0019005f
cc_22 N_4_27 N_A_3 0.0019005f
cc_23 N_4_63 N_A_5 0.0293916f
cc_24 N_4_64 N_A_1 0.011178f
cc_25 N_4_62 N_A_3 0.0377538f
cc_26 N_4_64 N_A_4 0.0381114f
cc_27 N_4_65 N_A_6 0.0502666f
x_PM_BUFx24_ASAP7_75t_R%Y vss Y N_M10_d N_M11_d N_M4_d N_M5_d N_M6_d N_M7_d
+ N_M8_d N_M9_d N_M12_d N_M13_d N_M14_d N_M15_d N_M16_d N_M17_d N_M18_d N_M19_d
+ N_M20_d N_M21_d N_M22_d N_M23_d N_M24_d N_M25_d N_M26_d N_M27_d N_M32_d
+ N_M33_d N_M34_d N_M35_d N_M36_d N_M37_d N_M38_d N_M39_d N_M40_d N_M41_d
+ N_M42_d N_M43_d N_M44_d N_M45_d N_M46_d N_M47_d N_M48_d N_M49_d N_M50_d
+ N_M51_d N_M52_d N_M53_d N_M54_d N_M55_d N_Y_84 N_Y_15 N_Y_16 N_Y_17 N_Y_18
+ N_Y_19 N_Y_20 N_Y_21 N_Y_22 N_Y_23 N_Y_24 N_Y_99 N_Y_100 N_Y_1 N_Y_3 N_Y_5
+ N_Y_7 N_Y_9 N_Y_11 N_Y_13 N_Y_85 N_Y_73 N_Y_96 N_Y_86 N_Y_87 N_Y_88 N_Y_89
+ N_Y_90 N_Y_91 N_Y_92 N_Y_93 N_Y_94 N_Y_95 N_Y_74 N_Y_75 N_Y_76 N_Y_77 N_Y_78
+ N_Y_79 N_Y_80 N_Y_81 N_Y_82 N_Y_83 N_Y_101 N_Y_4 N_Y_6 N_Y_8 N_Y_10 N_Y_12
+ N_Y_14 N_Y_2 PM_BUFx24_ASAP7_75t_R%Y
cc_28 N_Y_84 N_4_28 8.46074e-20
cc_29 N_Y_84 N_4_29 8.46074e-20
cc_30 N_Y_84 N_4_38 0.000188152f
cc_31 N_Y_84 N_4_40 0.000188152f
cc_32 N_Y_84 N_4_42 0.000188152f
cc_33 N_Y_84 N_4_44 0.000188152f
cc_34 N_Y_84 N_4_46 0.000188152f
cc_35 N_Y_84 N_4_48 0.000188152f
cc_36 N_Y_84 N_4_50 0.000188152f
cc_37 N_Y_15 N_4_52 9.40758e-20
cc_38 N_Y_16 N_4_52 0.00199222f
cc_39 N_Y_17 N_4_54 9.40758e-20
cc_40 N_Y_18 N_4_54 0.00199222f
cc_41 N_Y_19 N_4_56 9.40758e-20
cc_42 N_Y_20 N_4_56 0.00199222f
cc_43 N_Y_21 N_4_58 9.40758e-20
cc_44 N_Y_22 N_4_58 0.00199222f
cc_45 N_Y_23 N_4_60 0.00191837f
cc_46 N_Y_24 N_4_60 0.00191837f
cc_47 N_Y_99 N_4_69 0.000130613f
cc_48 N_Y_100 N_4_70 0.000130613f
cc_49 N_Y_99 N_4_66 0.000141876f
cc_50 N_Y_100 N_4_68 0.000141876f
cc_51 N_Y_99 N_4_71 0.000409416f
cc_52 N_Y_100 N_4_72 0.000409416f
cc_53 N_Y_1 N_4_1 0.000851355f
cc_54 N_Y_3 N_4_1 0.00110767f
cc_55 N_Y_5 N_4_1 0.00110767f
cc_56 N_Y_7 N_4_1 0.00110767f
cc_57 N_Y_9 N_4_1 0.00110767f
cc_58 N_Y_11 N_4_1 0.00110767f
cc_59 N_Y_13 N_4_1 0.00110767f
cc_60 N_Y_15 N_4_1 0.00110767f
cc_61 N_Y_17 N_4_1 0.00110767f
cc_62 N_Y_19 N_4_1 0.00110767f
cc_63 N_Y_21 N_4_1 0.00110767f
cc_64 N_Y_23 N_4_1 0.000675844f
cc_65 N_Y_24 N_4_1 0.000763117f
cc_66 N_Y_85 N_4_38 0.0286153f
cc_67 N_Y_73 N_4_38 0.0640603f
cc_68 N_Y_96 N_4_61 0.0286325f
cc_69 N_Y_86 N_4_41 0.0286728f
cc_70 N_Y_87 N_4_43 0.0286728f
cc_71 N_Y_88 N_4_45 0.0286728f
cc_72 N_Y_89 N_4_47 0.0286728f
cc_73 N_Y_90 N_4_49 0.0286728f
cc_74 N_Y_91 N_4_51 0.0286728f
cc_75 N_Y_92 N_4_53 0.0286728f
cc_76 N_Y_93 N_4_55 0.0286728f
cc_77 N_Y_94 N_4_57 0.0286728f
cc_78 N_Y_95 N_4_59 0.0286728f
cc_79 N_Y_74 N_4_41 0.0644059f
cc_80 N_Y_75 N_4_43 0.0644059f
cc_81 N_Y_76 N_4_45 0.0644059f
cc_82 N_Y_77 N_4_47 0.0644059f
cc_83 N_Y_78 N_4_49 0.0644059f
cc_84 N_Y_79 N_4_51 0.0644059f
cc_85 N_Y_80 N_4_53 0.0644059f
cc_86 N_Y_81 N_4_55 0.0644059f
cc_87 N_Y_82 N_4_57 0.0644059f
cc_88 N_Y_83 N_4_59 0.0643286f
cc_89 N_Y_101 N_4_73 0.0015825f
cc_90 N_Y_4 N_4_40 0.00189814f
cc_91 N_Y_3 N_4_41 0.00189814f
cc_92 N_Y_6 N_4_42 0.00189814f
cc_93 N_Y_5 N_4_43 0.00189814f
cc_94 N_Y_8 N_4_44 0.00189814f
cc_95 N_Y_7 N_4_45 0.00189814f
cc_96 N_Y_10 N_4_46 0.00189814f
cc_97 N_Y_9 N_4_47 0.00189814f
cc_98 N_Y_12 N_4_48 0.00189814f
cc_99 N_Y_11 N_4_49 0.00189814f
cc_100 N_Y_14 N_4_50 0.00189814f
cc_101 N_Y_13 N_4_51 0.00189814f
cc_102 N_Y_15 N_4_53 0.00189814f
cc_103 N_Y_17 N_4_55 0.00189814f
cc_104 N_Y_19 N_4_57 0.00189814f
cc_105 N_Y_21 N_4_59 0.00189814f
cc_106 N_Y_1 N_4_39 0.00206441f
cc_107 N_Y_2 N_4_39 0.00206441f
cc_108 N_Y_4 N_4_73 0.00717632f
cc_109 N_Y_12 N_4_73 0.00809259f
cc_110 N_Y_20 N_4_73 0.00886698f
cc_111 N_Y_100 N_4_73 0.00988674f
cc_112 N_Y_99 N_4_73 0.00989474f
cc_113 N_Y_76 N_4_1 0.0241889f
cc_114 N_Y_81 N_4_1 0.0249675f
cc_115 N_Y_84 N_4_61 0.0356786f
cc_116 N_Y_85 N_4_39 0.0357286f
cc_117 N_Y_86 N_4_40 0.0357369f
cc_118 N_Y_87 N_4_42 0.0357382f
cc_119 N_Y_88 N_4_44 0.0357382f
cc_120 N_Y_89 N_4_46 0.0357382f
cc_121 N_Y_90 N_4_48 0.0357382f
cc_122 N_Y_91 N_4_50 0.0357382f
cc_123 N_Y_92 N_4_52 0.0357382f
cc_124 N_Y_93 N_4_54 0.0357382f
cc_125 N_Y_94 N_4_56 0.0357382f
cc_126 N_Y_95 N_4_58 0.0357382f
cc_127 N_Y_84 N_4_60 0.0648128f

* End of included file BUFx24_ASAP7_75t_R.pex.sp.pxi
.ends
Vdd vdd 0 0.7
Vss vss 0 0
Vin in 0 PWL(0 0 100p 0 140p 0.7)
Xp1 vss vdd in p1 BUFx24_ASAP7_75t_R
Xp2 vss vdd p1 n1 BUFx24_ASAP7_75t_R
X1 vss vdd n1 o1 MCBUF d0=-2.666461e-02 d1=4.297024e-03 d2=-5.131626e-03 d3=-8.855288e-03 d4=1.783952e-02 d5=1.219229e-03 d6=-5.064340e-03 d7=3.326126e-02 d8=-9.126277e-03 d9=-2.330350e-02 d10=-2.535609e-02 d11=-9.707109e-03 d12=1.214887e-02 d13=1.572391e-02 d14=2.101286e-02 d15=3.417762e-02 d16=3.180085e-02 d17=1.231990e-02 d18=2.508620e-02 d19=1.270465e-02 d20=-9.767166e-03 d21=1.605163e-02 d22=1.961360e-03 d23=-2.989839e-03 d24=3.801922e-02 d25=1.527013e-02 d26=-8.046091e-03 d27=-4.517241e-04 d28=4.453404e-02 d29=-3.607974e-03 d30=1.471619e-02 d31=1.257324e-02 d32=1.055819e-02 d33=1.198646e-02 d34=-7.968366e-03 d35=-7.620779e-03 d36=-1.964317e-03 d37=-5.659960e-03 d38=1.611998e-02 d39=2.985944e-02 d40=-1.558835e-02 d41=1.124816e-02 d42=-1.729652e-02 d43=-1.190960e-02 d44=-3.436415e-03 d45=3.045708e-03 d46=-7.156407e-03 d47=-4.775847e-02 d48=2.693374e-02 d49=-4.040003e-03 d50=-1.085901e-02 d51=1.375766e-02 d52=-1.014779e-02 d53=-2.568434e-02 d54=1.019484e-02 d55=8.855887e-03
Cw1_0a o1 0 2.4750f
Rw1_0 o1 w1_0 200.250
Cw1_0b w1_0 0 2.4750f
Cw1_1a w1_0 0 2.4750f
Rw1_1 w1_0 w1_1 200.250
Cw1_1b w1_1 0 2.4750f
Cw1_2a w1_1 0 2.4750f
Rw1_2 w1_1 w1_2 200.250
Cw1_2b w1_2 0 2.4750f
Cw1_3a w1_2 0 2.4750f
Rw1_3 w1_2 w1_3 200.250
Cw1_3b w1_3 0 2.4750f
Cw1_4a w1_3 0 2.4750f
Rw1_4 w1_3 w1_4 200.250
Cw1_4b w1_4 0 2.4750f
Cw1_5a w1_4 0 2.4750f
Rw1_5 w1_4 w1_5 200.250
Cw1_5b w1_5 0 2.4750f
Cw1_6a w1_5 0 2.4750f
Rw1_6 w1_5 w1_6 200.250
Cw1_6b w1_6 0 2.4750f
Cw1_7a w1_6 0 2.4750f
Rw1_7 w1_6 w1_7 200.250
Cw1_7b w1_7 0 2.4750f
Cw1_8a w1_7 0 2.4750f
Rw1_8 w1_7 w1_8 200.250
Cw1_8b w1_8 0 2.4750f
Cw1_9a w1_8 0 2.4750f
Rw1_9 w1_8 n2 200.250
Cw1_9b n2 0 2.4750f
X2 vss vdd n2 o2 MCBUF d0=-1.442693e-02 d1=1.671609e-02 d2=8.010846e-03 d3=-2.019339e-02 d4=3.377682e-02 d5=6.035776e-03 d6=-2.020739e-02 d7=9.484947e-03 d8=3.389046e-03 d9=1.918198e-02 d10=-2.421850e-02 d11=2.048898e-02 d12=1.863524e-02 d13=1.401247e-02 d14=1.243621e-02 d15=2.560889e-02 d16=1.444998e-02 d17=3.406403e-03 d18=-1.465037e-02 d19=2.179855e-02 d20=1.937496e-02 d21=6.573585e-03 d22=3.844285e-03 d23=1.451478e-02 d24=-4.607239e-02 d25=6.922993e-03 d26=-4.577060e-02 d27=5.483076e-03 d28=2.075239e-02 d29=3.641631e-02 d30=-7.857720e-03 d31=9.004491e-03 d32=-3.763199e-04 d33=-4.068090e-02 d34=1.456952e-02 d35=6.113395e-04 d36=2.185700e-03 d37=-1.673247e-02 d38=1.283544e-04 d39=2.425834e-03 d40=2.482825e-02 d41=6.378627e-03 d42=6.617616e-02 d43=-6.752942e-03 d44=-4.058103e-03 d45=-9.179454e-05 d46=-1.427614e-02 d47=2.916144e-02 d48=1.297824e-02 d49=-2.293566e-02 d50=2.898986e-03 d51=2.239784e-02 d52=-2.565123e-02 d53=3.669048e-03 d54=-3.554980e-03 d55=4.453320e-02
Cw2_0a o2 0 2.4750f
Rw2_0 o2 w2_0 200.250
Cw2_0b w2_0 0 2.4750f
Cw2_1a w2_0 0 2.4750f
Rw2_1 w2_0 w2_1 200.250
Cw2_1b w2_1 0 2.4750f
Cw2_2a w2_1 0 2.4750f
Rw2_2 w2_1 w2_2 200.250
Cw2_2b w2_2 0 2.4750f
Cw2_3a w2_2 0 2.4750f
Rw2_3 w2_2 w2_3 200.250
Cw2_3b w2_3 0 2.4750f
Cw2_4a w2_3 0 2.4750f
Rw2_4 w2_3 w2_4 200.250
Cw2_4b w2_4 0 2.4750f
Cw2_5a w2_4 0 2.4750f
Rw2_5 w2_4 w2_5 200.250
Cw2_5b w2_5 0 2.4750f
Cw2_6a w2_5 0 2.4750f
Rw2_6 w2_5 w2_6 200.250
Cw2_6b w2_6 0 2.4750f
Cw2_7a w2_6 0 2.4750f
Rw2_7 w2_6 w2_7 200.250
Cw2_7b w2_7 0 2.4750f
Cw2_8a w2_7 0 2.4750f
Rw2_8 w2_7 w2_8 200.250
Cw2_8b w2_8 0 2.4750f
Cw2_9a w2_8 0 2.4750f
Rw2_9 w2_8 n3 200.250
Cw2_9b n3 0 2.4750f
X3 vss vdd n3 o3 MCBUF d0=8.643102e-03 d1=-6.763760e-03 d2=-9.625883e-03 d3=3.623858e-02 d4=-7.834761e-03 d5=4.358823e-02 d6=-2.834254e-02 d7=-2.710067e-03 d8=-3.596418e-03 d9=-1.229121e-02 d10=-3.089650e-03 d11=1.381389e-02 d12=-1.155698e-02 d13=-2.594056e-02 d14=2.603821e-02 d15=2.833961e-02 d16=-1.202723e-02 d17=6.580288e-03 d18=-4.724391e-02 d19=2.034602e-02 d20=-2.402264e-02 d21=-9.499326e-03 d22=4.133776e-02 d23=-2.274792e-02 d24=1.256995e-03 d25=-1.914554e-02 d26=-3.370811e-02 d27=-2.092987e-02 d28=5.931717e-03 d29=-2.357368e-02 d30=-1.016969e-02 d31=1.447423e-02 d32=-2.111078e-03 d33=-2.365749e-02 d34=2.886880e-02 d35=3.115930e-03 d36=2.714265e-02 d37=-1.874525e-02 d38=3.241398e-02 d39=-2.434456e-02 d40=-3.177214e-02 d41=-7.088043e-03 d42=-6.099239e-03 d43=5.765812e-03 d44=-9.636397e-03 d45=1.272271e-02 d46=2.581496e-02 d47=-1.135970e-02 d48=-2.486559e-02 d49=-6.653683e-03 d50=1.615669e-02 d51=1.610003e-02 d52=-5.639659e-03 d53=-1.758955e-02 d54=5.024504e-04 d55=1.885202e-02
Cw3_0a o3 0 2.4750f
Rw3_0 o3 w3_0 200.250
Cw3_0b w3_0 0 2.4750f
Cw3_1a w3_0 0 2.4750f
Rw3_1 w3_0 w3_1 200.250
Cw3_1b w3_1 0 2.4750f
Cw3_2a w3_1 0 2.4750f
Rw3_2 w3_1 w3_2 200.250
Cw3_2b w3_2 0 2.4750f
Cw3_3a w3_2 0 2.4750f
Rw3_3 w3_2 w3_3 200.250
Cw3_3b w3_3 0 2.4750f
Cw3_4a w3_3 0 2.4750f
Rw3_4 w3_3 w3_4 200.250
Cw3_4b w3_4 0 2.4750f
Cw3_5a w3_4 0 2.4750f
Rw3_5 w3_4 w3_5 200.250
Cw3_5b w3_5 0 2.4750f
Cw3_6a w3_5 0 2.4750f
Rw3_6 w3_5 w3_6 200.250
Cw3_6b w3_6 0 2.4750f
Cw3_7a w3_6 0 2.4750f
Rw3_7 w3_6 w3_7 200.250
Cw3_7b w3_7 0 2.4750f
Cw3_8a w3_7 0 2.4750f
Rw3_8 w3_7 w3_8 200.250
Cw3_8b w3_8 0 2.4750f
Cw3_9a w3_8 0 2.4750f
Rw3_9 w3_8 n4 200.250
Cw3_9b n4 0 2.4750f
X4 vss vdd n4 o4 MCBUF d0=-1.251550e-02 d1=2.510930e-02 d2=5.053073e-03 d3=6.251419e-03 d4=-1.088893e-02 d5=2.629881e-02 d6=1.636986e-03 d7=-2.702989e-02 d8=1.614175e-02 d9=-7.020511e-03 d10=2.097199e-02 d11=3.965165e-03 d12=-1.088278e-02 d13=4.019602e-03 d14=-8.362222e-03 d15=-1.463843e-02 d16=1.202440e-03 d17=1.639002e-02 d18=2.155948e-03 d19=-7.946610e-04 d20=-9.549189e-03 d21=1.149718e-02 d22=5.911598e-03 d23=1.872726e-02 d24=7.651750e-03 d25=4.063833e-02 d26=-2.855486e-02 d27=-1.856182e-04 d28=1.079357e-02 d29=1.757535e-02 d30=-2.783802e-02 d31=-2.202533e-02 d32=1.591155e-05 d33=2.047112e-02 d34=2.131666e-02 d35=-2.754560e-02 d36=3.230006e-03 d37=2.270021e-02 d38=1.312570e-03 d39=-1.845941e-02 d40=-1.260395e-02 d41=-2.412956e-02 d42=2.309205e-02 d43=-4.039848e-03 d44=-7.218498e-03 d45=-1.553810e-02 d46=-1.810707e-03 d47=-1.617316e-02 d48=-1.745707e-02 d49=1.094844e-05 d50=-3.507417e-03 d51=9.335801e-03 d52=3.521837e-03 d53=2.286246e-02 d54=-6.575840e-05 d55=5.656335e-03
Cw4_0a o4 0 2.4750f
Rw4_0 o4 w4_0 200.250
Cw4_0b w4_0 0 2.4750f
Cw4_1a w4_0 0 2.4750f
Rw4_1 w4_0 w4_1 200.250
Cw4_1b w4_1 0 2.4750f
Cw4_2a w4_1 0 2.4750f
Rw4_2 w4_1 w4_2 200.250
Cw4_2b w4_2 0 2.4750f
Cw4_3a w4_2 0 2.4750f
Rw4_3 w4_2 w4_3 200.250
Cw4_3b w4_3 0 2.4750f
Cw4_4a w4_3 0 2.4750f
Rw4_4 w4_3 w4_4 200.250
Cw4_4b w4_4 0 2.4750f
Cw4_5a w4_4 0 2.4750f
Rw4_5 w4_4 w4_5 200.250
Cw4_5b w4_5 0 2.4750f
Cw4_6a w4_5 0 2.4750f
Rw4_6 w4_5 w4_6 200.250
Cw4_6b w4_6 0 2.4750f
Cw4_7a w4_6 0 2.4750f
Rw4_7 w4_6 w4_7 200.250
Cw4_7b w4_7 0 2.4750f
Cw4_8a w4_7 0 2.4750f
Rw4_8 w4_7 w4_8 200.250
Cw4_8b w4_8 0 2.4750f
Cw4_9a w4_8 0 2.4750f
Rw4_9 w4_8 n5 200.250
Cw4_9b n5 0 2.4750f
X5 vss vdd n5 o5 MCBUF d0=5.001384e-03 d1=-1.428265e-02 d2=2.295507e-02 d3=-9.739948e-03 d4=-2.874765e-02 d5=2.406408e-02 d6=1.296519e-02 d7=-9.769940e-03 d8=1.857452e-02 d9=1.877146e-02 d10=1.389771e-02 d11=-2.110308e-02 d12=4.073097e-03 d13=-1.858632e-02 d14=-1.064748e-02 d15=-9.725650e-03 d16=-1.503348e-02 d17=9.956144e-03 d18=-1.395169e-02 d19=1.235467e-02 d20=3.958059e-03 d21=-1.053823e-02 d22=3.939102e-03 d23=1.358703e-02 d24=2.207138e-02 d25=-4.060965e-03 d26=3.312854e-02 d27=1.144105e-02 d28=2.398222e-02 d29=-2.442815e-02 d30=-1.898160e-02 d31=2.330203e-02 d32=-3.425758e-03 d33=9.423324e-03 d34=2.313249e-02 d35=-2.614575e-02 d36=9.165939e-03 d37=3.685765e-02 d38=1.565661e-02 d39=2.438598e-03 d40=1.126384e-02 d41=9.189324e-04 d42=1.517351e-02 d43=2.502795e-02 d44=-3.456825e-03 d45=1.147016e-02 d46=6.423010e-03 d47=1.460557e-02 d48=1.633412e-02 d49=-1.920517e-02 d50=2.244487e-02 d51=1.681433e-02 d52=-1.960799e-02 d53=-4.544395e-03 d54=-2.638877e-02 d55=-4.617600e-03
Cw5_0a o5 0 2.4750f
Rw5_0 o5 w5_0 200.250
Cw5_0b w5_0 0 2.4750f
Cw5_1a w5_0 0 2.4750f
Rw5_1 w5_0 w5_1 200.250
Cw5_1b w5_1 0 2.4750f
Cw5_2a w5_1 0 2.4750f
Rw5_2 w5_1 w5_2 200.250
Cw5_2b w5_2 0 2.4750f
Cw5_3a w5_2 0 2.4750f
Rw5_3 w5_2 w5_3 200.250
Cw5_3b w5_3 0 2.4750f
Cw5_4a w5_3 0 2.4750f
Rw5_4 w5_3 w5_4 200.250
Cw5_4b w5_4 0 2.4750f
Cw5_5a w5_4 0 2.4750f
Rw5_5 w5_4 w5_5 200.250
Cw5_5b w5_5 0 2.4750f
Cw5_6a w5_5 0 2.4750f
Rw5_6 w5_5 w5_6 200.250
Cw5_6b w5_6 0 2.4750f
Cw5_7a w5_6 0 2.4750f
Rw5_7 w5_6 w5_7 200.250
Cw5_7b w5_7 0 2.4750f
Cw5_8a w5_7 0 2.4750f
Rw5_8 w5_7 w5_8 200.250
Cw5_8b w5_8 0 2.4750f
Cw5_9a w5_8 0 2.4750f
Rw5_9 w5_8 n6 200.250
Cw5_9b n6 0 2.4750f
X6 vss vdd n6 o6 MCBUF d0=6.856855e-03 d1=-2.078806e-02 d2=-1.364020e-02 d3=-1.557983e-02 d4=-1.218155e-02 d5=-1.365491e-02 d6=-1.914092e-02 d7=1.134125e-02 d8=-3.251002e-03 d9=-1.454937e-02 d10=1.911221e-02 d11=-9.758982e-03 d12=1.738819e-02 d13=-2.226938e-02 d14=2.690120e-02 d15=-7.572733e-03 d16=-1.687301e-02 d17=8.353778e-03 d18=-2.408922e-02 d19=-1.934407e-02 d20=5.153631e-03 d21=-8.229036e-03 d22=8.157879e-03 d23=3.372263e-03 d24=5.428086e-03 d25=3.175491e-03 d26=1.396038e-02 d27=7.377574e-04 d28=2.125512e-02 d29=1.830985e-02 d30=-3.577569e-02 d31=-3.186669e-02 d32=2.964168e-02 d33=-7.507957e-03 d34=4.183825e-03 d35=-1.370601e-03 d36=5.819767e-03 d37=4.171631e-02 d38=-1.240330e-02 d39=1.928248e-03 d40=8.279281e-04 d41=-1.934866e-02 d42=-1.549263e-02 d43=-4.300435e-03 d44=4.097469e-04 d45=7.869806e-03 d46=-3.569264e-02 d47=-2.835760e-02 d48=3.130176e-02 d49=-2.616520e-03 d50=1.598980e-02 d51=-7.110231e-03 d52=-1.247101e-02 d53=3.993287e-02 d54=-2.218779e-02 d55=-1.614580e-02
Cw6_0a o6 0 2.4750f
Rw6_0 o6 w6_0 200.250
Cw6_0b w6_0 0 2.4750f
Cw6_1a w6_0 0 2.4750f
Rw6_1 w6_0 w6_1 200.250
Cw6_1b w6_1 0 2.4750f
Cw6_2a w6_1 0 2.4750f
Rw6_2 w6_1 w6_2 200.250
Cw6_2b w6_2 0 2.4750f
Cw6_3a w6_2 0 2.4750f
Rw6_3 w6_2 w6_3 200.250
Cw6_3b w6_3 0 2.4750f
Cw6_4a w6_3 0 2.4750f
Rw6_4 w6_3 w6_4 200.250
Cw6_4b w6_4 0 2.4750f
Cw6_5a w6_4 0 2.4750f
Rw6_5 w6_4 w6_5 200.250
Cw6_5b w6_5 0 2.4750f
Cw6_6a w6_5 0 2.4750f
Rw6_6 w6_5 w6_6 200.250
Cw6_6b w6_6 0 2.4750f
Cw6_7a w6_6 0 2.4750f
Rw6_7 w6_6 w6_7 200.250
Cw6_7b w6_7 0 2.4750f
Cw6_8a w6_7 0 2.4750f
Rw6_8 w6_7 w6_8 200.250
Cw6_8b w6_8 0 2.4750f
Cw6_9a w6_8 0 2.4750f
Rw6_9 w6_8 n7 200.250
Cw6_9b n7 0 2.4750f
Xend vss vdd n7 oend BUFx24_ASAP7_75t_R
.tran 1p 1150p 0 1p
.end
