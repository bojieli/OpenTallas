* NGSPICE file created from ihp_sg13g2_rom_slice.ext - technology: ihp-sg13g2

.subckt ihp_sg13g2_rom_slice VGND VPWR WL_PRESENT EN_PRESENT PRE_PRESENT Q_PRESENT
+ WL_ABSENT EN_ABSENT PRE_ABSENT Q_ABSENT
X0 VGND EN_ABSENT NROW_ABSENT/S NMASK_ABSENT/w_n81_n155.t0 sg13_lv_nmos ad=0.34p pd=2.68u as=0.34p ps=2.68u w=1u l=0.13u
X1 VPWR PRE_ABSENT BL_ABSENT VPWR sg13_lv_pmos ad=0.34p pd=2.68u as=0.34p ps=2.68u w=1u l=0.13u
X2 VPWR BL_PRESENT Q_PRESENT VPWR sg13_lv_pmos ad=9.24322p pd=77.045u as=0.77302p ps=7.205u w=1u l=0.13u
X3 NROW_PRESENT/S WL_PRESENT BL_PRESENT NROW_PRESENT/w_n81_n155.t0 sg13_lv_nmos ad=1.22242p pd=10.465u as=1.20022p ps=12.905u w=1u l=0.13u
X4 VPWR PRE_PRESENT BL_PRESENT VPWR sg13_lv_pmos ad=0 pd=0 as=0 ps=0 w=1u l=0.13u
X5 VGND BL_PRESENT Q_PRESENT NSENSE_PRESENT/w_n81_n155.t0 sg13_lv_nmos ad=9.72802p pd=81.085u as=0 ps=0 w=1u l=0.13u
X6 VPWR BL_ABSENT Q_ABSENT VPWR sg13_lv_pmos ad=0 pd=0 as=0.77302p ps=7.205u w=1u l=0.13u
X7 VGND BL_ABSENT Q_ABSENT NSENSE_ABSENT/w_n81_n155.t0 sg13_lv_nmos ad=0 pd=0 as=0 ps=0 w=1u l=0.13u
X8 VGND EN_PRESENT NROW_PRESENT/S NMASK_PRESENT/w_n81_n155.t0 sg13_lv_nmos ad=0 pd=0 as=0 ps=0 w=1u l=0.13u
X9 NROW_ABSENT/S WL_ABSENT ROM_DRAIN_ABSENT NROW_ABSENT/w_n81_n155.t0 sg13_lv_nmos ad=1.22242p pd=10.465u as=0.37962p ps=3.545u w=1u l=0.13u
C0 Q_PRESENT PRE_PRESENT 0
C1 BL_ABSENT EN_ABSENT 0.05152f
C2 Q_PRESENT VPWR 0.3696f
C3 WL_ABSENT Q_ABSENT 0
C4 PRE_ABSENT VPWR 0.16045f
C5 ROM_DRAIN_ABSENT NROW_ABSENT/S 0.14106f
C6 EN_PRESENT Q_PRESENT 0
C7 Q_PRESENT BL_PRESENT 0.3688f
C8 WL_PRESENT Q_PRESENT 0
C9 PRE_ABSENT BL_PRESENT 0
C10 Q_ABSENT EN_ABSENT 0
C11 WL_ABSENT PRE_ABSENT 0
C12 PRE_PRESENT VPWR 0.15139f
C13 WL_ABSENT ROM_DRAIN_ABSENT 0.10518f
C14 NROW_ABSENT/S VPWR 0.02708f
C15 Q_ABSENT BL_ABSENT 0.3682f
C16 PRE_PRESENT BL_PRESENT 0.14738f
C17 WL_PRESENT PRE_PRESENT 0
C18 EN_PRESENT VPWR 0.01665f
C19 BL_PRESENT VPWR 0.63007f
C20 WL_PRESENT VPWR 0.01661f
C21 Q_PRESENT NROW_PRESENT/S 0.00301f
C22 BL_ABSENT Q_PRESENT 0
C23 EN_PRESENT BL_PRESENT 0.05153f
C24 WL_ABSENT NROW_ABSENT/S 0.00944f
C25 EN_PRESENT WL_PRESENT 0.00324f
C26 WL_ABSENT VPWR 0.01661f
C27 WL_PRESENT BL_PRESENT 0.15104f
C28 BL_ABSENT PRE_ABSENT 0.14738f
C29 BL_ABSENT ROM_DRAIN_ABSENT 0.03054f
C30 EN_ABSENT NROW_ABSENT/S 0.00944f
C31 WL_ABSENT BL_PRESENT 0
C32 EN_ABSENT VPWR 0.01665f
C33 Q_ABSENT PRE_ABSENT 0
C34 Q_ABSENT ROM_DRAIN_ABSENT 0
C35 NROW_PRESENT/S VPWR 0.02708f
C36 BL_ABSENT NROW_ABSENT/S 0.07493f
C37 BL_ABSENT VPWR 0.68178f
C38 WL_ABSENT EN_ABSENT 0.00324f
C39 EN_PRESENT NROW_PRESENT/S 0.00944f
C40 NROW_PRESENT/S BL_PRESENT 0.21617f
C41 WL_PRESENT NROW_PRESENT/S 0.00944f
C42 Q_ABSENT NROW_ABSENT/S 0.00301f
C43 Q_ABSENT VPWR 0.35973f
C44 WL_ABSENT BL_ABSENT 0.04379f
R0 VGND NMASK_ABSENT/w_n81_n155.t0 2518.52
R1 VGND NROW_PRESENT/w_n81_n155.t0 2518.52
R2 VGND NSENSE_PRESENT/w_n81_n155.t0 2518.52
R3 VGND NSENSE_ABSENT/w_n81_n155.t0 2518.52
R4 VGND NMASK_PRESENT/w_n81_n155.t0 2518.52
R5 VGND NROW_ABSENT/w_n81_n155.t0 2518.52
R6 Q_ABSENT.n0 Q_ABSENT 0.548
R7 Q_ABSENT Q_ABSENT.n0 12.0176
R8 Q_ABSENT.n0 Q_ABSENT 10.1896
R9 Q_PRESENT.n0 Q_PRESENT 0.548
R10 Q_PRESENT Q_PRESENT.n0 12.0176
R11 Q_PRESENT.n0 Q_PRESENT 10.1896
R12 VPWR VPWR.n3 0.730083
R13 VPWR.n3 VPWR.n2 2.83383
R14 VPWR.n2 VPWR.n1 1.89175
R15 VPWR.n1 VPWR.n0 1.65092
R16 VPWR VPWR.n3 0.227167
R17 VPWR.n2 VPWR 0.227167
R18 VPWR.n1 VPWR 16.2201
R19 VPWR.n0 VPWR 0.227167
R20 VPWR.n0 VPWR 3.0605
R21 VGND VGND.n4 2.14675
R22 VGND.n4 VGND.n3 1.41717
R23 VGND VGND.n4 0.478625
R24 VGND.n3 VGND 0.478625
R25 VGND.n3 VGND.n1 1.87758
R26 VGND.n1 VGND.n2 3.05342
R27 VGND.n2 VGND 0.478625
R28 VGND.n2 VGND 1.89529
R29 VGND.n1 VGND.n0 7941
R30 VGND.n0 VGND 1275
R31 VGND VGND.n0 2025
R32 BL_ABSENT.n0 BL_ABSENT 5.18961
R33 BL_ABSENT BL_ABSENT.n0 0.763958
R34 BL_ABSENT.n0 BL_ABSENT 8.02874
R35 BL_PRESENT.n1 BL_PRESENT 5.37211
R36 BL_PRESENT.n1 BL_PRESENT 7.84624
R37 BL_PRESENT.n1 BL_PRESENT 0.846083
R38 BL_PRESENT BL_PRESENT.n0 0.763958
R39 BL_PRESENT.n0 BL_PRESENT 8.02874
R40 BL_PRESENT.n0 BL_PRESENT 5.18961
C45 BL_PRESENT.n0 VGND 0.26752f ; **FLOATING
C46 BL_PRESENT.n1 VGND 0.28093f ; **FLOATING
C47 BL_ABSENT.n0 VGND 0.29303f ; **FLOATING
C48 VPWR.n0 VGND 0.04617f ; **FLOATING
C49 VPWR.n1 VGND 0.04123f ; **FLOATING
C50 VPWR.n2 VGND 0.04481f ; **FLOATING
C51 VPWR.n3 VGND 0.0343f ; **FLOATING
C52 Q_PRESENT.n0 VGND 0.24287f ; **FLOATING
C53 Q_ABSENT.n0 VGND 0.23814f ; **FLOATING
C54 NROW_ABSENT/S VGND 0.59768f
C55 ROM_DRAIN_ABSENT VGND 0.09067f
C56 WL_ABSENT VGND 0.35956f
C57 EN_PRESENT VGND 0.38236f
C58 Q_ABSENT VGND 1.11192f
C59 PRE_PRESENT VGND 0.29563f
C60 VPWR VGND 3.68413f
C61 NROW_PRESENT/S VGND 0.59768f
C62 BL_PRESENT VGND 2.25952f
C63 WL_PRESENT VGND 0.3607f
C64 Q_PRESENT VGND 1.10672f
C65 BL_ABSENT VGND 2.36672f
C66 PRE_ABSENT VGND 0.29235f
C67 EN_ABSENT VGND 0.38236f
.ends
