* NGSPICE file created from ihp_sg13g2_rom_slice.ext - technology: ihp-sg13g2

.subckt ihp_sg13g2_rom_slice VGND VPWR WL_PRESENT EN_PRESENT PRE_PRESENT Q_PRESENT
+ WL_ABSENT EN_ABSENT PRE_ABSENT Q_ABSENT
X0 VGND EN_ABSENT NROW_ABSENT/S NMASK_ABSENT/w_n81_n155.t0 sg13_lv_nmos ad=0.34p pd=2.68u as=0.34p ps=2.68u w=1u l=0.13u
X1 VPWR PRE_ABSENT BL_ABSENT VPWR sg13_lv_pmos ad=0.34p pd=2.68u as=0.34p ps=2.68u w=1u l=0.13u
X2 VPWR BL_PRESENT Q_PRESENT VPWR sg13_lv_pmos ad=9.24322p pd=77.045u as=0.77302p ps=7.205u w=1u l=0.13u
X3 NROW_PRESENT/S WL_PRESENT BL_PRESENT NROW_PRESENT/w_n81_n155.t0 sg13_lv_nmos ad=1.22242p pd=10.465u as=1.20022p ps=12.905u w=1u l=0.13u
X4 VPWR PRE_PRESENT BL_PRESENT VPWR sg13_lv_pmos ad=0 pd=0 as=0 ps=0 w=1u l=0.13u
X5 VGND BL_PRESENT Q_PRESENT NSENSE_PRESENT/w_n81_n155.t0 sg13_lv_nmos ad=9.72802p pd=81.085u as=0 ps=0 w=1u l=0.13u
X6 VPWR BL_ABSENT Q_ABSENT VPWR sg13_lv_pmos ad=0 pd=0 as=0.77302p ps=7.205u w=1u l=0.13u
X7 VGND BL_ABSENT Q_ABSENT NSENSE_ABSENT/w_n81_n155.t0 sg13_lv_nmos ad=0 pd=0 as=0 ps=0 w=1u l=0.13u
X8 VGND EN_PRESENT NROW_PRESENT/S NMASK_PRESENT/w_n81_n155.t0 sg13_lv_nmos ad=0 pd=0 as=0 ps=0 w=1u l=0.13u
X9 NROW_ABSENT/S WL_ABSENT ROM_DRAIN_ABSENT NROW_ABSENT/w_n81_n155.t0 sg13_lv_nmos ad=1.22242p pd=10.465u as=0.37962p ps=3.545u w=1u l=0.13u
C0 EN_PRESENT BL_PRESENT 0.0459f
C1 EN_PRESENT Q_PRESENT 0
C2 BL_ABSENT EN_ABSENT 0.04589f
C3 BL_ABSENT Q_PRESENT 0
C4 Q_ABSENT VPWR 0.32125f
C5 PRE_ABSENT BL_ABSENT 0.13143f
C6 WL_ABSENT VPWR 0.01497f
C7 PRE_PRESENT WL_PRESENT 0
C8 Q_ABSENT ROM_DRAIN_ABSENT 0
C9 WL_ABSENT ROM_DRAIN_ABSENT 0.09421f
C10 Q_PRESENT BL_PRESENT 0.33082f
C11 PRE_ABSENT BL_PRESENT 0
C12 BL_ABSENT NROW_ABSENT/S 0.06514f
C13 EN_ABSENT NROW_ABSENT/S 0.00807f
C14 VPWR NROW_PRESENT/S 0.02438f
C15 VPWR WL_PRESENT 0.01497f
C16 Q_ABSENT BL_ABSENT 0.33025f
C17 PRE_PRESENT BL_PRESENT 0.13143f
C18 PRE_PRESENT Q_PRESENT 0
C19 BL_ABSENT WL_ABSENT 0.03855f
C20 Q_ABSENT EN_ABSENT 0
C21 NROW_PRESENT/S WL_PRESENT 0.00807f
C22 WL_ABSENT EN_ABSENT 0.00297f
C23 WL_ABSENT BL_PRESENT 0
C24 Q_ABSENT PRE_ABSENT 0
C25 EN_PRESENT VPWR 0.01502f
C26 PRE_ABSENT WL_ABSENT 0
C27 BL_ABSENT VPWR 0.61917f
C28 BL_ABSENT ROM_DRAIN_ABSENT 0.02663f
C29 EN_PRESENT NROW_PRESENT/S 0.00807f
C30 VPWR EN_ABSENT 0.01502f
C31 Q_ABSENT NROW_ABSENT/S 0.0029f
C32 VPWR BL_PRESENT 0.57126f
C33 EN_PRESENT WL_PRESENT 0.00297f
C34 VPWR Q_PRESENT 0.33056f
C35 WL_ABSENT NROW_ABSENT/S 0.00807f
C36 PRE_ABSENT VPWR 0.14952f
C37 BL_PRESENT NROW_PRESENT/S 0.19207f
C38 Q_PRESENT NROW_PRESENT/S 0.0029f
C39 BL_PRESENT WL_PRESENT 0.13463f
C40 Q_PRESENT WL_PRESENT 0
C41 VPWR NROW_ABSENT/S 0.02438f
C42 Q_ABSENT WL_ABSENT 0
C43 NROW_ABSENT/S ROM_DRAIN_ABSENT 0.12677f
C44 PRE_PRESENT VPWR 0.14106f
R0 VGND NMASK_ABSENT/w_n81_n155.t0 2518.52
R1 VGND NROW_PRESENT/w_n81_n155.t0 2518.52
R2 VGND NSENSE_PRESENT/w_n81_n155.t0 2518.52
R3 VGND NSENSE_ABSENT/w_n81_n155.t0 2518.52
R4 VGND NMASK_PRESENT/w_n81_n155.t0 2518.52
R5 VGND NROW_ABSENT/w_n81_n155.t0 2518.52
R6 Q_ABSENT.n0 Q_ABSENT 0.6605
R7 Q_ABSENT Q_ABSENT.n0 20.4489
R8 Q_ABSENT.n0 Q_ABSENT 18.2452
R9 Q_PRESENT.n0 Q_PRESENT 0.6605
R10 Q_PRESENT Q_PRESENT.n0 20.4489
R11 Q_PRESENT.n0 Q_PRESENT 18.2452
R12 VPWR VPWR.n3 0.944667
R13 VPWR.n3 VPWR.n2 3.66717
R14 VPWR.n2 VPWR.n1 2.448
R15 VPWR.n1 VPWR.n0 2.13633
R16 VPWR VPWR.n3 0.293833
R17 VPWR.n2 VPWR 0.293833
R18 VPWR.n1 VPWR 34.2847
R19 VPWR.n0 VPWR 0.293833
R20 VPWR.n0 VPWR 3.9605
R21 VGND VGND.n4 2.778
R22 VGND.n4 VGND.n3 1.83383
R23 VGND VGND.n4 0.61925
R24 VGND.n3 VGND 0.61925
R25 VGND.n3 VGND.n1 2.42967
R26 VGND.n1 VGND.n2 3.95133
R27 VGND.n2 VGND 0.61925
R28 VGND.n2 VGND 2.45258
R29 VGND.n1 VGND.n0 7959
R30 VGND.n0 VGND 1275
R31 VGND VGND.n0 2025
R32 BL_ABSENT.n0 BL_ABSENT 9.24523
R33 BL_ABSENT BL_ABSENT.n0 0.920833
R34 BL_ABSENT.n0 BL_ABSENT 12.6875
R35 BL_PRESENT.n1 BL_PRESENT 9.46523
R36 BL_PRESENT.n1 BL_PRESENT 12.4675
R37 BL_PRESENT.n1 BL_PRESENT 1.01983
R38 BL_PRESENT BL_PRESENT.n0 0.920833
R39 BL_PRESENT.n0 BL_PRESENT 12.6875
R40 BL_PRESENT.n0 BL_PRESENT 9.24523
C45 BL_PRESENT.n0 VGND 0.24901f ; **FLOATING
C46 BL_PRESENT.n1 VGND 0.26024f ; **FLOATING
C47 BL_ABSENT.n0 VGND 0.2729f ; **FLOATING
C48 VPWR.n0 VGND 0.04143f ; **FLOATING
C49 VPWR.n1 VGND 0.03704f ; **FLOATING
C50 VPWR.n2 VGND 0.04021f ; **FLOATING
C51 VPWR.n3 VGND 0.03078f ; **FLOATING
C52 Q_PRESENT.n0 VGND 0.22198f ; **FLOATING
C53 Q_ABSENT.n0 VGND 0.21743f ; **FLOATING
C54 NROW_ABSENT/S VGND 0.53821f
C55 ROM_DRAIN_ABSENT VGND 0.08233f
C56 WL_ABSENT VGND 0.33132f
C57 EN_PRESENT VGND 0.35132f
C58 Q_ABSENT VGND 1.00675f
C59 PRE_PRESENT VGND 0.26984f
C60 VPWR VGND 3.36144f
C61 NROW_PRESENT/S VGND 0.53821f
C62 BL_PRESENT VGND 2.04656f
C63 WL_PRESENT VGND 0.33239f
C64 Q_PRESENT VGND 1.0018f
C65 BL_ABSENT VGND 2.14802f
C66 PRE_ABSENT VGND 0.26663f
C67 EN_ABSENT VGND 0.35132f
.ends
