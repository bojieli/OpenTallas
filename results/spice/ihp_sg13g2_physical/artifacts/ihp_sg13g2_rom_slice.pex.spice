* NGSPICE file created from ihp_sg13g2_rom_slice.ext - technology: ihp-sg13g2

.subckt ihp_sg13g2_rom_slice VGND VPWR WL_PRESENT EN_PRESENT PRE_PRESENT Q_PRESENT
+ WL_ABSENT EN_ABSENT PRE_ABSENT Q_ABSENT
X0 VGND EN_ABSENT NROW_ABSENT/S VGND sg13_lv_nmos ad=0.34p pd=2.68u as=0.34p ps=2.68u w=1u l=0.13u
X1 VPWR PRE_ABSENT BL_ABSENT VPWR sg13_lv_pmos ad=0.34p pd=2.68u as=0.34p ps=2.68u w=1u l=0.13u
X2 VPWR BL_PRESENT Q_PRESENT VPWR sg13_lv_pmos ad=9.24322p pd=77.045u as=0.77302p ps=7.205u w=1u l=0.13u
X3 VPWR PRE_PRESENT BL_PRESENT VPWR sg13_lv_pmos ad=0 pd=0 as=1.20022p ps=12.905u w=1u l=0.13u
X4 NROW_PRESENT/S WL_PRESENT BL_PRESENT VGND sg13_lv_nmos ad=1.22242p pd=10.465u as=0 ps=0 w=1u l=0.13u
X5 VPWR BL_ABSENT Q_ABSENT VPWR sg13_lv_pmos ad=0 pd=0 as=0.77302p ps=7.205u w=1u l=0.13u
X6 VGND BL_PRESENT Q_PRESENT VGND sg13_lv_nmos ad=9.72802p pd=81.085u as=0 ps=0 w=1u l=0.13u
X7 VGND BL_ABSENT Q_ABSENT VGND sg13_lv_nmos ad=0 pd=0 as=0 ps=0 w=1u l=0.13u
X8 VGND EN_PRESENT NROW_PRESENT/S VGND sg13_lv_nmos ad=0 pd=0 as=0 ps=0 w=1u l=0.13u
X9 NROW_ABSENT/S WL_ABSENT ROM_DRAIN_ABSENT VGND sg13_lv_nmos ad=1.22242p pd=10.465u as=0.37962p ps=3.545u w=1u l=0.13u
C0 WL_ABSENT EN_ABSENT 0.00297f
C1 Q_ABSENT VPWR 0.32125f
C2 BL_PRESENT Q_PRESENT 0.33082f
C3 ROM_DRAIN_ABSENT Q_ABSENT 0
C4 WL_ABSENT Q_ABSENT 0
C5 EN_PRESENT Q_PRESENT 0
C6 PRE_PRESENT Q_PRESENT 0
C7 NROW_PRESENT/S Q_PRESENT 0.0029f
C8 NROW_ABSENT/S VPWR 0.02438f
C9 Q_ABSENT EN_ABSENT 0
C10 NROW_ABSENT/S ROM_DRAIN_ABSENT 0.12677f
C11 NROW_ABSENT/S WL_ABSENT 0.00807f
C12 NROW_ABSENT/S EN_ABSENT 0.00807f
C13 VPWR Q_PRESENT 0.33056f
C14 NROW_ABSENT/S Q_ABSENT 0.0029f
C15 BL_ABSENT PRE_ABSENT 0.13143f
C16 BL_PRESENT WL_PRESENT 0.13463f
C17 BL_PRESENT PRE_ABSENT 0
C18 EN_PRESENT WL_PRESENT 0.00297f
C19 WL_PRESENT PRE_PRESENT 0
C20 NROW_PRESENT/S WL_PRESENT 0.00807f
C21 WL_PRESENT VPWR 0.01497f
C22 EN_PRESENT BL_PRESENT 0.0459f
C23 VPWR PRE_ABSENT 0.14952f
C24 BL_PRESENT PRE_PRESENT 0.13143f
C25 NROW_PRESENT/S BL_PRESENT 0.19207f
C26 WL_ABSENT PRE_ABSENT 0
C27 EN_PRESENT NROW_PRESENT/S 0.00807f
C28 VPWR BL_ABSENT 0.61917f
C29 ROM_DRAIN_ABSENT BL_ABSENT 0.02663f
C30 WL_ABSENT BL_ABSENT 0.03855f
C31 BL_ABSENT EN_ABSENT 0.04589f
C32 BL_PRESENT VPWR 0.57126f
C33 Q_ABSENT PRE_ABSENT 0
C34 WL_ABSENT BL_PRESENT 0
C35 EN_PRESENT VPWR 0.01502f
C36 PRE_PRESENT VPWR 0.14106f
C37 NROW_PRESENT/S VPWR 0.02438f
C38 Q_ABSENT BL_ABSENT 0.33025f
C39 NROW_ABSENT/S BL_ABSENT 0.06514f
C40 WL_PRESENT Q_PRESENT 0
C41 WL_ABSENT VPWR 0.01497f
C42 WL_ABSENT ROM_DRAIN_ABSENT 0.09421f
C43 VPWR EN_ABSENT 0.01502f
C44 BL_ABSENT Q_PRESENT 0
C45 NROW_ABSENT/S VGND 0.45521f
C46 ROM_DRAIN_ABSENT VGND 0.08193f
C47 WL_ABSENT VGND 0.22342f
C48 EN_PRESENT VGND 0.29422f
C49 Q_ABSENT VGND 0.76511f
C50 NROW_PRESENT/S VGND 0.45521f
C51 BL_PRESENT VGND 1.63979f
C52 WL_PRESENT VGND 0.22326f
C53 PRE_PRESENT VGND 0.11835f
C54 VPWR VGND 2.01695f
C55 Q_PRESENT VGND 0.75511f
C56 BL_ABSENT VGND 1.50998f
C57 PRE_ABSENT VGND 0.10923f
C58 EN_ABSENT VGND 0.29422f
.ends
