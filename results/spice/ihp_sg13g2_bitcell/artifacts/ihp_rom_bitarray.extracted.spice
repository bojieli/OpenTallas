* NGSPICE file created from ihp_rom_bitarray.ext - technology: ihp-sg13g2

.subckt ihp_rom_bitarray WL0 WL1 WL2 WL3 WL4 WL5 WL6 WL7 BL0 BL1 BL2 BL3
X0 a_n266_n198# WL5 BL2 a_n266_n198# sg13_lv_nmos ad=57f pd=0.68u as=0.102p ps=1.28u w=0.3u l=0.13u
X1 a_225_64# WL0 a_n266_n198# a_n266_n198# sg13_lv_nmos ad=0.102p pd=1.28u as=0.114p ps=1.36u w=0.3u l=0.13u
X2 a_n266_n198# WL7 BL2 a_n266_n198# sg13_lv_nmos ad=0.114p pd=1.36u as=0.102p ps=1.28u w=0.3u l=0.13u
X3 a_n266_n198# WL5 a_327_786# a_n266_n198# sg13_lv_nmos ad=57f pd=0.68u as=0.102p ps=1.28u w=0.3u l=0.13u
X4 a_21_370# WL2 a_n266_n198# a_n266_n198# sg13_lv_nmos ad=0.102p pd=1.28u as=57f ps=0.68u w=0.3u l=0.13u
X5 BL1 WL4 a_n266_n198# a_n266_n198# sg13_lv_nmos ad=0.102p pd=1.28u as=57f ps=0.68u w=0.3u l=0.13u
X6 a_n266_n198# WL7 BL0 a_n266_n198# sg13_lv_nmos ad=0.114p pd=1.36u as=0.102p ps=1.28u w=0.3u l=0.13u
X7 a_n266_n198# WL5 BL0 a_n266_n198# sg13_lv_nmos ad=57f pd=0.68u as=0.102p ps=1.28u w=0.3u l=0.13u
X8 a_225_676# WL4 a_n266_n198# a_n266_n198# sg13_lv_nmos ad=0.102p pd=1.28u as=57f ps=0.68u w=0.3u l=0.13u
X9 a_n266_n198# WL7 a_327_1092# a_n266_n198# sg13_lv_nmos ad=0.114p pd=1.36u as=0.102p ps=1.28u w=0.3u l=0.13u
X10 BL1 WL6 a_n266_n198# a_n266_n198# sg13_lv_nmos ad=0.102p pd=1.28u as=57f ps=0.68u w=0.3u l=0.13u
X11 BL3 WL4 a_n266_n198# a_n266_n198# sg13_lv_nmos ad=0.102p pd=1.28u as=57f ps=0.68u w=0.3u l=0.13u
X12 a_225_982# WL6 a_n266_n198# a_n266_n198# sg13_lv_nmos ad=0.102p pd=1.28u as=57f ps=0.68u w=0.3u l=0.13u
X13 BL1 WL0 a_n266_n198# a_n266_n198# sg13_lv_nmos ad=0.102p pd=1.28u as=0.114p ps=1.36u w=0.3u l=0.13u
X14 a_n266_n198# WL1 a_123_174# a_n266_n198# sg13_lv_nmos ad=57f pd=0.68u as=0.102p ps=1.28u w=0.3u l=0.13u
X15 BL3 WL6 a_n266_n198# a_n266_n198# sg13_lv_nmos ad=0.102p pd=1.28u as=57f ps=0.68u w=0.3u l=0.13u
X16 a_n266_n198# WL1 BL2 a_n266_n198# sg13_lv_nmos ad=57f pd=0.68u as=0.102p ps=1.28u w=0.3u l=0.13u
X17 a_21_676# WL4 a_n266_n198# a_n266_n198# sg13_lv_nmos ad=0.102p pd=1.28u as=57f ps=0.68u w=0.3u l=0.13u
X18 a_n266_n198# WL3 a_123_480# a_n266_n198# sg13_lv_nmos ad=57f pd=0.68u as=0.102p ps=1.28u w=0.3u l=0.13u
X19 a_n266_n198# WL1 a_327_174# a_n266_n198# sg13_lv_nmos ad=57f pd=0.68u as=0.102p ps=1.28u w=0.3u l=0.13u
X20 a_n266_n198# WL3 BL2 a_n266_n198# sg13_lv_nmos ad=57f pd=0.68u as=0.102p ps=1.28u w=0.3u l=0.13u
X21 a_21_982# WL6 a_n266_n198# a_n266_n198# sg13_lv_nmos ad=0.102p pd=1.28u as=57f ps=0.68u w=0.3u l=0.13u
X22 a_n266_n198# WL3 a_327_480# a_n266_n198# sg13_lv_nmos ad=57f pd=0.68u as=0.102p ps=1.28u w=0.3u l=0.13u
X23 a_n266_n198# WL1 BL0 a_n266_n198# sg13_lv_nmos ad=57f pd=0.68u as=0.102p ps=1.28u w=0.3u l=0.13u
X24 BL3 WL0 a_n266_n198# a_n266_n198# sg13_lv_nmos ad=0.102p pd=1.28u as=0.114p ps=1.36u w=0.3u l=0.13u
X25 BL1 WL2 a_n266_n198# a_n266_n198# sg13_lv_nmos ad=0.102p pd=1.28u as=57f ps=0.68u w=0.3u l=0.13u
X26 a_n266_n198# WL7 a_123_1092# a_n266_n198# sg13_lv_nmos ad=0.114p pd=1.36u as=0.102p ps=1.28u w=0.3u l=0.13u
X27 a_n266_n198# WL3 BL0 a_n266_n198# sg13_lv_nmos ad=57f pd=0.68u as=0.102p ps=1.28u w=0.3u l=0.13u
X28 a_225_370# WL2 a_n266_n198# a_n266_n198# sg13_lv_nmos ad=0.102p pd=1.28u as=57f ps=0.68u w=0.3u l=0.13u
X29 BL3 WL2 a_n266_n198# a_n266_n198# sg13_lv_nmos ad=0.102p pd=1.28u as=57f ps=0.68u w=0.3u l=0.13u
X30 a_n266_n198# WL5 a_123_786# a_n266_n198# sg13_lv_nmos ad=57f pd=0.68u as=0.102p ps=1.28u w=0.3u l=0.13u
X31 a_21_64# WL0 a_n266_n198# a_n266_n198# sg13_lv_nmos ad=0.102p pd=1.28u as=0.114p ps=1.36u w=0.3u l=0.13u
.ends
