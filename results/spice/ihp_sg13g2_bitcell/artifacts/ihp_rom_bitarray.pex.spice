* NGSPICE file created from ihp_rom_bitarray.ext - technology: ihp-sg13g2

.subckt ihp_rom_bitarray WL0 WL1 WL2 WL3 WL4 WL5 WL6 WL7 BL0 BL1 BL2 BL3
X0 a_n266_n198# WL5 BL2 a_n266_n198# sg13_lv_nmos ad=57f pd=0.68u as=0.102p ps=1.28u w=0.3u l=0.13u
X1 a_225_64# WL0 a_n266_n198# a_n266_n198# sg13_lv_nmos ad=0.102p pd=1.28u as=0.114p ps=1.36u w=0.3u l=0.13u
X2 a_n266_n198# WL7 BL2 a_n266_n198# sg13_lv_nmos ad=0.114p pd=1.36u as=0.102p ps=1.28u w=0.3u l=0.13u
X3 a_n266_n198# WL5 a_327_786# a_n266_n198# sg13_lv_nmos ad=57f pd=0.68u as=0.102p ps=1.28u w=0.3u l=0.13u
X4 a_21_370# WL2 a_n266_n198# a_n266_n198# sg13_lv_nmos ad=0.102p pd=1.28u as=57f ps=0.68u w=0.3u l=0.13u
X5 BL1 WL4 a_n266_n198# a_n266_n198# sg13_lv_nmos ad=0.102p pd=1.28u as=57f ps=0.68u w=0.3u l=0.13u
X6 a_n266_n198# WL7 BL0 a_n266_n198# sg13_lv_nmos ad=0.114p pd=1.36u as=0.102p ps=1.28u w=0.3u l=0.13u
X7 a_n266_n198# WL5 BL0 a_n266_n198# sg13_lv_nmos ad=57f pd=0.68u as=0.102p ps=1.28u w=0.3u l=0.13u
X8 a_225_676# WL4 a_n266_n198# a_n266_n198# sg13_lv_nmos ad=0.102p pd=1.28u as=57f ps=0.68u w=0.3u l=0.13u
X9 a_n266_n198# WL7 a_327_1092# a_n266_n198# sg13_lv_nmos ad=0.114p pd=1.36u as=0.102p ps=1.28u w=0.3u l=0.13u
X10 BL1 WL6 a_n266_n198# a_n266_n198# sg13_lv_nmos ad=0.102p pd=1.28u as=57f ps=0.68u w=0.3u l=0.13u
X11 BL3 WL4 a_n266_n198# a_n266_n198# sg13_lv_nmos ad=0.102p pd=1.28u as=57f ps=0.68u w=0.3u l=0.13u
X12 a_225_982# WL6 a_n266_n198# a_n266_n198# sg13_lv_nmos ad=0.102p pd=1.28u as=57f ps=0.68u w=0.3u l=0.13u
X13 BL1 WL0 a_n266_n198# a_n266_n198# sg13_lv_nmos ad=0.102p pd=1.28u as=0.114p ps=1.36u w=0.3u l=0.13u
X14 a_n266_n198# WL1 a_123_174# a_n266_n198# sg13_lv_nmos ad=57f pd=0.68u as=0.102p ps=1.28u w=0.3u l=0.13u
X15 BL3 WL6 a_n266_n198# a_n266_n198# sg13_lv_nmos ad=0.102p pd=1.28u as=57f ps=0.68u w=0.3u l=0.13u
X16 a_n266_n198# WL1 BL2 a_n266_n198# sg13_lv_nmos ad=57f pd=0.68u as=0.102p ps=1.28u w=0.3u l=0.13u
X17 a_21_676# WL4 a_n266_n198# a_n266_n198# sg13_lv_nmos ad=0.102p pd=1.28u as=57f ps=0.68u w=0.3u l=0.13u
X18 a_n266_n198# WL3 a_123_480# a_n266_n198# sg13_lv_nmos ad=57f pd=0.68u as=0.102p ps=1.28u w=0.3u l=0.13u
X19 a_n266_n198# WL1 a_327_174# a_n266_n198# sg13_lv_nmos ad=57f pd=0.68u as=0.102p ps=1.28u w=0.3u l=0.13u
X20 a_n266_n198# WL3 BL2 a_n266_n198# sg13_lv_nmos ad=57f pd=0.68u as=0.102p ps=1.28u w=0.3u l=0.13u
X21 a_21_982# WL6 a_n266_n198# a_n266_n198# sg13_lv_nmos ad=0.102p pd=1.28u as=57f ps=0.68u w=0.3u l=0.13u
X22 a_n266_n198# WL3 a_327_480# a_n266_n198# sg13_lv_nmos ad=57f pd=0.68u as=0.102p ps=1.28u w=0.3u l=0.13u
X23 a_n266_n198# WL1 BL0 a_n266_n198# sg13_lv_nmos ad=57f pd=0.68u as=0.102p ps=1.28u w=0.3u l=0.13u
X24 BL3 WL0 a_n266_n198# a_n266_n198# sg13_lv_nmos ad=0.102p pd=1.28u as=0.114p ps=1.36u w=0.3u l=0.13u
X25 BL1 WL2 a_n266_n198# a_n266_n198# sg13_lv_nmos ad=0.102p pd=1.28u as=57f ps=0.68u w=0.3u l=0.13u
X26 a_n266_n198# WL7 a_123_1092# a_n266_n198# sg13_lv_nmos ad=0.114p pd=1.36u as=0.102p ps=1.28u w=0.3u l=0.13u
X27 a_n266_n198# WL3 BL0 a_n266_n198# sg13_lv_nmos ad=57f pd=0.68u as=0.102p ps=1.28u w=0.3u l=0.13u
X28 a_225_370# WL2 a_n266_n198# a_n266_n198# sg13_lv_nmos ad=0.102p pd=1.28u as=57f ps=0.68u w=0.3u l=0.13u
X29 BL3 WL2 a_n266_n198# a_n266_n198# sg13_lv_nmos ad=0.102p pd=1.28u as=57f ps=0.68u w=0.3u l=0.13u
X30 a_n266_n198# WL5 a_123_786# a_n266_n198# sg13_lv_nmos ad=57f pd=0.68u as=0.102p ps=1.28u w=0.3u l=0.13u
X31 a_21_64# WL0 a_n266_n198# a_n266_n198# sg13_lv_nmos ad=0.102p pd=1.28u as=0.114p ps=1.36u w=0.3u l=0.13u
C0 WL5 WL4 0.0256f
C1 a_123_480# BL0 0.0809f
C2 a_123_174# WL1 0.00259f
C3 BL3 WL1 0.00233f
C4 a_123_1092# WL6 0
C5 a_327_174# WL1 0.00275f
C6 WL7 BL2 0.00417f
C7 BL1 a_123_786# 0.08359f
C8 BL1 WL0 0.00417f
C9 a_123_174# BL2 0.0809f
C10 BL3 BL2 1.6182f
C11 WL4 a_21_676# 0.00275f
C12 WL3 a_123_480# 0.00259f
C13 a_327_174# BL2 0.0809f
C14 BL1 BL0 1.6182f
C15 BL1 a_225_64# 0.0809f
C16 WL5 a_123_786# 0.00259f
C17 WL5 a_327_786# 0.00275f
C18 WL6 BL2 0.00169f
C19 BL3 WL4 0.00497f
C20 a_225_370# BL2 0.08359f
C21 BL3 WL2 0.00497f
C22 a_21_64# WL1 0
C23 WL5 BL0 0.00497f
C24 BL1 WL3 0.00169f
C25 BL1 a_123_480# 0.08359f
C26 a_225_370# WL2 0.00259f
C27 a_123_1092# BL2 0.0809f
C28 BL3 a_327_480# 0.08359f
C29 BL1 a_225_676# 0.0809f
C30 a_21_676# BL0 0.08359f
C31 BL3 a_327_786# 0.08359f
C32 a_123_174# WL0 0
C33 BL3 WL0 0.00497f
C34 a_327_174# WL0 0
C35 WL7 BL0 0.00497f
C36 BL2 WL1 0.00417f
C37 a_123_174# BL0 0.0809f
C38 WL5 a_225_676# 0
C39 BL1 a_225_982# 0.0809f
C40 a_21_982# BL0 0.08359f
C41 BL3 a_225_64# 0.0809f
C42 WL2 WL1 0.06187f
C43 WL7 a_327_1092# 0.00275f
C44 WL6 BL0 0.00233f
C45 WL5 BL1 0.00169f
C46 BL3 WL3 0.00233f
C47 a_21_370# WL2 0.00275f
C48 BL3 a_327_1092# 0.08359f
C49 WL4 BL2 0.00169f
C50 a_21_64# WL0 0.00275f
C51 WL2 BL2 0.00169f
C52 BL1 a_21_676# 0.0809f
C53 a_21_64# BL0 0.08359f
C54 BL3 a_225_676# 0.0809f
C55 a_225_370# WL3 0
C56 a_327_1092# WL6 0
C57 a_123_1092# BL0 0.0809f
C58 BL1 WL7 0.00169f
C59 WL0 WL1 0.0256f
C60 a_225_982# WL7 0
C61 BL1 a_123_174# 0.08359f
C62 a_327_480# BL2 0.0809f
C63 BL1 a_21_982# 0.0809f
C64 a_123_786# BL2 0.0809f
C65 WL1 BL0 0.00497f
C66 WL5 a_21_676# 0
C67 BL3 a_225_982# 0.0809f
C68 BL2 a_327_786# 0.0809f
C69 a_225_64# WL1 0
C70 BL2 WL0 0.00169f
C71 a_21_370# BL0 0.08359f
C72 BL1 WL6 0.00417f
C73 a_225_370# BL1 0.0809f
C74 WL5 BL3 0.00233f
C75 a_123_786# WL4 0
C76 WL2 a_327_480# 0
C77 a_225_64# BL2 0.08359f
C78 a_225_982# WL6 0.00259f
C79 WL4 a_327_786# 0
C80 a_21_370# WL3 0
C81 WL4 BL0 0.00233f
C82 WL5 WL6 0.06187f
C83 BL1 a_21_64# 0.0809f
C84 WL3 BL2 0.00417f
C85 WL2 BL0 0.00233f
C86 BL1 a_123_1092# 0.08359f
C87 a_327_1092# BL2 0.0809f
C88 a_123_480# BL2 0.0809f
C89 BL3 WL7 0.00233f
C90 WL7 a_21_982# 0
C91 WL3 WL4 0.06187f
C92 BL1 WL1 0.00169f
C93 a_225_676# BL2 0.08359f
C94 BL3 a_327_174# 0.08359f
C95 WL2 WL3 0.0256f
C96 WL7 WL6 0.0256f
C97 BL1 a_21_370# 0.0809f
C98 WL2 a_123_480# 0
C99 a_123_786# BL0 0.0809f
C100 WL0 BL0 0.00233f
C101 BL1 BL2 1.6182f
C102 BL3 WL6 0.00497f
C103 a_225_676# WL4 0.00259f
C104 a_225_370# BL3 0.0809f
C105 a_225_64# WL0 0.00259f
C106 a_21_982# WL6 0.00275f
C107 a_225_982# BL2 0.08359f
C108 WL3 a_327_480# 0.00275f
C109 BL1 WL4 0.00417f
C110 WL7 a_123_1092# 0.00259f
C111 WL5 BL2 0.00417f
C112 BL1 WL2 0.00417f
C113 WL3 BL0 0.00497f
C114 WL0 a_n266_n198# 0.22658f
C115 WL1 a_n266_n198# 0.16769f
C116 WL2 a_n266_n198# 0.16761f
C117 WL3 a_n266_n198# 0.16756f
C118 WL4 a_n266_n198# 0.16756f
C119 WL5 a_n266_n198# 0.16761f
C120 WL6 a_n266_n198# 0.16769f
C121 BL3 a_n266_n198# 0.76764f
C122 BL1 a_n266_n198# 0.43963f
C123 BL2 a_n266_n198# 0.43963f
C124 BL0 a_n266_n198# 0.75192f
C125 WL7 a_n266_n198# 0.22658f
C126 a_225_64# a_n266_n198# 0.07737f ; **FLOATING
C127 a_21_64# a_n266_n198# 0.09266f ; **FLOATING
C128 a_327_174# a_n266_n198# 0.09266f ; **FLOATING
C129 a_123_174# a_n266_n198# 0.07737f ; **FLOATING
C130 a_225_370# a_n266_n198# 0.07737f ; **FLOATING
C131 a_21_370# a_n266_n198# 0.09266f ; **FLOATING
C132 a_327_480# a_n266_n198# 0.09266f ; **FLOATING
C133 a_123_480# a_n266_n198# 0.07737f ; **FLOATING
C134 a_225_676# a_n266_n198# 0.07737f ; **FLOATING
C135 a_21_676# a_n266_n198# 0.09266f ; **FLOATING
C136 a_327_786# a_n266_n198# 0.09266f ; **FLOATING
C137 a_123_786# a_n266_n198# 0.07737f ; **FLOATING
C138 a_225_982# a_n266_n198# 0.07737f ; **FLOATING
C139 a_21_982# a_n266_n198# 0.09266f ; **FLOATING
C140 a_327_1092# a_n266_n198# 0.09266f ; **FLOATING
C141 a_123_1092# a_n266_n198# 0.07737f ; **FLOATING
.ends
