* NGSPICE file created from ihp_rom_bitarray.ext - technology: ihp-sg13g2

.subckt ihp_rom_bitarray VSS WL0 WL1 WL2 WL3 WL4 WL5 WL6 WL7 BL0 BL1 BL2 BL3
X0 VSS WL5 BL2 VSS sg13_lv_nmos ad=57f pd=0.68u as=0.102p ps=1.28u w=0.3u l=0.13u
X1 a_225_64# WL0 VSS VSS sg13_lv_nmos ad=0.102p pd=1.28u as=0.114p ps=1.36u w=0.3u l=0.13u
X2 VSS WL7 BL2 VSS sg13_lv_nmos ad=0.114p pd=1.36u as=0.102p ps=1.28u w=0.3u l=0.13u
X3 VSS WL5 a_327_786# VSS sg13_lv_nmos ad=57f pd=0.68u as=0.102p ps=1.28u w=0.3u l=0.13u
X4 a_21_370# WL2 VSS VSS sg13_lv_nmos ad=0.102p pd=1.28u as=57f ps=0.68u w=0.3u l=0.13u
X5 BL1 WL4 VSS VSS sg13_lv_nmos ad=0.102p pd=1.28u as=57f ps=0.68u w=0.3u l=0.13u
X6 VSS WL7 BL0 VSS sg13_lv_nmos ad=0.114p pd=1.36u as=0.102p ps=1.28u w=0.3u l=0.13u
X7 VSS WL5 BL0 VSS sg13_lv_nmos ad=57f pd=0.68u as=0.102p ps=1.28u w=0.3u l=0.13u
X8 a_225_676# WL4 VSS VSS sg13_lv_nmos ad=0.102p pd=1.28u as=57f ps=0.68u w=0.3u l=0.13u
X9 VSS WL7 a_327_1092# VSS sg13_lv_nmos ad=0.114p pd=1.36u as=0.102p ps=1.28u w=0.3u l=0.13u
X10 BL1 WL6 VSS VSS sg13_lv_nmos ad=0.102p pd=1.28u as=57f ps=0.68u w=0.3u l=0.13u
X11 BL3 WL4 VSS VSS sg13_lv_nmos ad=0.102p pd=1.28u as=57f ps=0.68u w=0.3u l=0.13u
X12 a_225_982# WL6 VSS VSS sg13_lv_nmos ad=0.102p pd=1.28u as=57f ps=0.68u w=0.3u l=0.13u
X13 BL1 WL0 VSS VSS sg13_lv_nmos ad=0.102p pd=1.28u as=0.114p ps=1.36u w=0.3u l=0.13u
X14 VSS WL1 a_123_174# VSS sg13_lv_nmos ad=57f pd=0.68u as=0.102p ps=1.28u w=0.3u l=0.13u
X15 BL3 WL6 VSS VSS sg13_lv_nmos ad=0.102p pd=1.28u as=57f ps=0.68u w=0.3u l=0.13u
X16 VSS WL1 BL2 VSS sg13_lv_nmos ad=57f pd=0.68u as=0.102p ps=1.28u w=0.3u l=0.13u
X17 a_21_676# WL4 VSS VSS sg13_lv_nmos ad=0.102p pd=1.28u as=57f ps=0.68u w=0.3u l=0.13u
X18 VSS WL3 a_123_480# VSS sg13_lv_nmos ad=57f pd=0.68u as=0.102p ps=1.28u w=0.3u l=0.13u
X19 VSS WL1 a_327_174# VSS sg13_lv_nmos ad=57f pd=0.68u as=0.102p ps=1.28u w=0.3u l=0.13u
X20 VSS WL3 BL2 VSS sg13_lv_nmos ad=57f pd=0.68u as=0.102p ps=1.28u w=0.3u l=0.13u
X21 a_21_982# WL6 VSS VSS sg13_lv_nmos ad=0.102p pd=1.28u as=57f ps=0.68u w=0.3u l=0.13u
X22 VSS WL3 a_327_480# VSS sg13_lv_nmos ad=57f pd=0.68u as=0.102p ps=1.28u w=0.3u l=0.13u
X23 VSS WL1 BL0 VSS sg13_lv_nmos ad=57f pd=0.68u as=0.102p ps=1.28u w=0.3u l=0.13u
X24 BL3 WL0 VSS VSS sg13_lv_nmos ad=0.102p pd=1.28u as=0.114p ps=1.36u w=0.3u l=0.13u
X25 BL1 WL2 VSS VSS sg13_lv_nmos ad=0.102p pd=1.28u as=57f ps=0.68u w=0.3u l=0.13u
X26 VSS WL7 a_123_1092# VSS sg13_lv_nmos ad=0.114p pd=1.36u as=0.102p ps=1.28u w=0.3u l=0.13u
X27 VSS WL3 BL0 VSS sg13_lv_nmos ad=57f pd=0.68u as=0.102p ps=1.28u w=0.3u l=0.13u
X28 a_225_370# WL2 VSS VSS sg13_lv_nmos ad=0.102p pd=1.28u as=57f ps=0.68u w=0.3u l=0.13u
X29 BL3 WL2 VSS VSS sg13_lv_nmos ad=0.102p pd=1.28u as=57f ps=0.68u w=0.3u l=0.13u
X30 VSS WL5 a_123_786# VSS sg13_lv_nmos ad=57f pd=0.68u as=0.102p ps=1.28u w=0.3u l=0.13u
X31 a_21_64# WL0 VSS VSS sg13_lv_nmos ad=0.102p pd=1.28u as=0.114p ps=1.36u w=0.3u l=0.13u
C0 a_123_480# WL2 0
C1 WL6 BL2 0.00169f
C2 BL3 WL1 0.00233f
C3 a_123_174# WL1 0.00259f
C4 WL4 BL2 0.00169f
C5 BL3 WL7 0.00233f
C6 a_21_370# WL2 0.00275f
C7 WL0 WL1 0.0256f
C8 a_327_174# WL1 0.00275f
C9 a_123_480# BL2 0.0809f
C10 a_327_1092# BL2 0.0809f
C11 WL7 a_21_982# 0
C12 BL1 a_123_786# 0.08359f
C13 a_225_982# WL7 0
C14 BL3 WL2 0.00497f
C15 BL1 a_225_676# 0.0809f
C16 a_327_1092# WL6 0
C17 BL1 a_21_676# 0.0809f
C18 BL3 BL2 1.6182f
C19 a_123_174# BL2 0.0809f
C20 a_225_982# BL2 0.08359f
C21 BL3 a_225_370# 0.0809f
C22 WL3 BL0 0.00497f
C23 WL0 BL2 0.00169f
C24 a_123_1092# BL0 0.0809f
C25 a_327_174# BL2 0.0809f
C26 WL5 BL2 0.00417f
C27 BL3 WL6 0.00497f
C28 BL1 BL0 1.6182f
C29 a_21_982# WL6 0.00275f
C30 a_225_982# WL6 0.00259f
C31 WL4 BL3 0.00497f
C32 a_21_64# BL0 0.08359f
C33 BL1 a_225_64# 0.0809f
C34 WL5 WL6 0.06187f
C35 BL3 a_327_1092# 0.08359f
C36 WL4 WL5 0.0256f
C37 a_327_480# WL3 0.00275f
C38 a_123_786# BL2 0.0809f
C39 WL1 BL0 0.00497f
C40 BL1 WL3 0.00169f
C41 BL1 a_123_1092# 0.08359f
C42 WL7 BL0 0.00497f
C43 a_225_64# WL1 0
C44 BL2 a_225_676# 0.08359f
C45 a_225_982# BL3 0.0809f
C46 WL2 BL0 0.00233f
C47 BL3 WL0 0.00497f
C48 a_327_174# BL3 0.08359f
C49 BL3 WL5 0.00233f
C50 a_123_174# WL0 0
C51 WL4 a_123_786# 0
C52 BL1 a_21_64# 0.0809f
C53 a_327_174# WL0 0
C54 WL4 a_225_676# 0.00259f
C55 WL4 a_21_676# 0.00275f
C56 BL1 WL1 0.00169f
C57 a_123_1092# WL7 0.00259f
C58 a_225_64# BL2 0.08359f
C59 a_327_786# BL2 0.0809f
C60 a_327_480# WL2 0
C61 WL2 WL3 0.0256f
C62 a_21_64# WL1 0
C63 BL1 WL7 0.00169f
C64 WL6 BL0 0.00233f
C65 BL1 WL2 0.00417f
C66 WL4 BL0 0.00233f
C67 WL5 a_123_786# 0.00259f
C68 BL3 a_225_676# 0.0809f
C69 a_327_480# BL2 0.0809f
C70 WL3 BL2 0.00417f
C71 a_123_1092# BL2 0.0809f
C72 a_123_480# BL0 0.0809f
C73 WL4 a_327_786# 0
C74 a_225_370# WL3 0
C75 BL1 BL2 1.6182f
C76 WL5 a_225_676# 0
C77 WL5 a_21_676# 0
C78 a_21_370# BL0 0.08359f
C79 BL1 a_225_370# 0.0809f
C80 a_123_1092# WL6 0
C81 WL2 WL1 0.06187f
C82 a_123_174# BL0 0.0809f
C83 WL4 WL3 0.06187f
C84 BL1 WL6 0.00417f
C85 a_21_982# BL0 0.08359f
C86 BL3 a_225_64# 0.0809f
C87 WL0 BL0 0.00233f
C88 BL3 a_327_786# 0.08359f
C89 a_123_480# WL3 0.00259f
C90 WL4 BL1 0.00417f
C91 WL5 BL0 0.00497f
C92 WL1 BL2 0.00417f
C93 a_225_64# WL0 0.00259f
C94 a_123_480# BL1 0.08359f
C95 WL7 BL2 0.00417f
C96 WL5 a_327_786# 0.00275f
C97 a_21_370# WL3 0
C98 a_327_480# BL3 0.08359f
C99 WL2 BL2 0.00169f
C100 BL3 WL3 0.00233f
C101 BL1 a_21_370# 0.0809f
C102 WL2 a_225_370# 0.00259f
C103 WL7 WL6 0.0256f
C104 a_123_786# BL0 0.0809f
C105 BL1 a_123_174# 0.08359f
C106 BL1 a_21_982# 0.0809f
C107 BL1 a_225_982# 0.0809f
C108 BL1 WL0 0.00417f
C109 BL1 WL5 0.00169f
C110 a_225_370# BL2 0.08359f
C111 a_327_1092# WL7 0.00275f
C112 a_21_676# BL0 0.08359f
C113 a_21_64# WL0 0.00275f
C114 WL0 VSS 0.22702f
C115 WL1 VSS 0.16796f
C116 WL2 VSS 0.16782f
C117 WL3 VSS 0.16769f
C118 WL4 VSS 0.16767f
C119 WL5 VSS 0.16768f
C120 WL6 VSS 0.16775f
C121 BL3 VSS 0.76764f
C122 BL1 VSS 0.43963f
C123 BL2 VSS 0.43963f
C124 BL0 VSS 0.75192f
C125 WL7 VSS 0.22662f
C126 a_225_64# VSS 0.07737f ; **FLOATING
C127 a_21_64# VSS 0.09266f ; **FLOATING
C128 a_327_174# VSS 0.09266f ; **FLOATING
C129 a_123_174# VSS 0.07737f ; **FLOATING
C130 a_225_370# VSS 0.07737f ; **FLOATING
C131 a_21_370# VSS 0.09266f ; **FLOATING
C132 a_327_480# VSS 0.09266f ; **FLOATING
C133 a_123_480# VSS 0.07737f ; **FLOATING
C134 a_225_676# VSS 0.07737f ; **FLOATING
C135 a_21_676# VSS 0.09266f ; **FLOATING
C136 a_327_786# VSS 0.09266f ; **FLOATING
C137 a_123_786# VSS 0.07737f ; **FLOATING
C138 a_225_982# VSS 0.07737f ; **FLOATING
C139 a_21_982# VSS 0.09266f ; **FLOATING
C140 a_327_1092# VSS 0.09266f ; **FLOATING
C141 a_123_1092# VSS 0.07737f ; **FLOATING
.ends
