* NGSPICE file created from sky130_rom_slice.ext - technology: sky130A

.subckt sky130_rom_slice VGND VPWR WL_PRESENT EN_PRESENT PRE_PRESENT Q_PRESENT WL_ABSENT
+ EN_ABSENT PRE_ABSENT Q_ABSENT
X0 NMASK_ABSENT/S.t0 NMASK_ABSENT/G.t0 NMASK_ABSENT/D.t0 NMASK_ABSENT/B.t0 sky130_fd_pr__nfet_01v8 ad=0.29 pd=2.58 as=0.29 ps=2.58 w=1 l=0.15
X1 PPRE_ABSENT/S.t0 PPRE_ABSENT/G.t0 PPRE_ABSENT/D.t0 PPRE_ABSENT/B.t0 sky130_fd_pr__pfet_01v8 ad=0.29 pd=2.58 as=0.29 ps=2.58 w=1 l=0.15
X2 PSENSE_PRESENT/S.t0 PSENSE_PRESENT/G.t0 PSENSE_PRESENT/D.t0 PSENSE_PRESENT/B.t0 sky130_fd_pr__pfet_01v8 ad=0 pd=0 as=0 ps=0 w=1 l=0.15
X3 NROW_PRESENT/S.t0 NROW_PRESENT/G.t0 NROW_PRESENT/D.t0 NROW_PRESENT/B.t0 sky130_fd_pr__nfet_01v8 ad=0 pd=0 as=0 ps=0 w=1 l=0.15
X4 PPRE_PRESENT/S.t0 PPRE_PRESENT/G.t0 PPRE_PRESENT/D.t0 PPRE_PRESENT/B.t0 sky130_fd_pr__pfet_01v8 ad=0 pd=0 as=0 ps=0 w=1 l=0.15
X5 NSENSE_PRESENT/S.t0 NSENSE_PRESENT/G.t0 NSENSE_PRESENT/D.t0 NSENSE_PRESENT/B.t0 sky130_fd_pr__nfet_01v8 ad=0 pd=0 as=0 ps=0 w=1 l=0.15
X6 PSENSE_ABSENT/S.t0 PSENSE_ABSENT/G.t0 PSENSE_ABSENT/D.t0 PSENSE_ABSENT/B.t0 sky130_fd_pr__pfet_01v8 ad=0 pd=0 as=0 ps=0 w=1 l=0.15
X7 NSENSE_ABSENT/S.t0 NSENSE_ABSENT/G.t0 NSENSE_ABSENT/D.t0 NSENSE_ABSENT/B.t0 sky130_fd_pr__nfet_01v8 ad=0 pd=0 as=0 ps=0 w=1 l=0.15
X8 NMASK_PRESENT/S.t0 NMASK_PRESENT/G.t0 NMASK_PRESENT/D.t0 NMASK_PRESENT/B.t0 sky130_fd_pr__nfet_01v8 ad=0 pd=0 as=0 ps=0 w=1 l=0.15
X9 NROW_ABSENT/S.t0 NROW_ABSENT/G.t0 NROW_ABSENT/D.t0 NROW_ABSENT/B.t0 sky130_fd_pr__nfet_01v8 ad=0 pd=0 as=0 ps=0 w=1 l=0.15
C0 EN_ABSENT Q_ABSENT 0.00123f
C1 NROW_PRESENT/S WL_PRESENT 0.03938f
C2 EN_PRESENT NROW_PRESENT/S 0.04023f
C3 BL_ABSENT ROM_DRAIN_ABSENT 0.08674f
C4 VPWR Q_ABSENT 0.5099f
C5 BL_PRESENT PRE_PRESENT 0.22368f
C6 NROW_ABSENT/S ROM_DRAIN_ABSENT 0.18921f
C7 VPWR PRE_PRESENT 0.40039f
C8 WL_ABSENT ROM_DRAIN_ABSENT 0.06195f
C9 Q_PRESENT NROW_PRESENT/S 0.00288f
C10 BL_PRESENT WL_PRESENT 0.2383f
C11 EN_PRESENT BL_PRESENT 0.22942f
C12 WL_PRESENT VPWR 0.02399f
C13 BL_ABSENT NROW_ABSENT/S 0.0847f
C14 EN_PRESENT VPWR 0.01581f
C15 Q_PRESENT WL_ABSENT 0
C16 BL_ABSENT WL_ABSENT 0.17102f
C17 BL_ABSENT PRE_ABSENT 0.22368f
C18 BL_PRESENT Q_PRESENT 0.26187f
C19 Q_ABSENT ROM_DRAIN_ABSENT 0
C20 NROW_ABSENT/S WL_ABSENT 0.03979f
C21 BL_ABSENT EN_ABSENT 0.22942f
C22 WL_PRESENT PRE_PRESENT 0.00108f
C23 Q_PRESENT VPWR 0.51192f
C24 BL_ABSENT VPWR 0.98441f
C25 BL_PRESENT NROW_PRESENT/S 0.27778f
C26 NROW_ABSENT/S EN_ABSENT 0.04023f
C27 PRE_ABSENT WL_ABSENT 0.00108f
C28 EN_PRESENT WL_PRESENT 0.00662f
C29 NROW_PRESENT/S VPWR 0.02976f
C30 BL_ABSENT Q_ABSENT 0.26186f
C31 NROW_ABSENT/S VPWR 0.02976f
C32 EN_ABSENT WL_ABSENT 0.00662f
C33 BL_PRESENT WL_ABSENT 0.00128f
C34 Q_PRESENT PRE_PRESENT 0
C35 PRE_ABSENT BL_PRESENT 0.00133f
C36 VPWR WL_ABSENT 0.02399f
C37 NROW_ABSENT/S Q_ABSENT 0.00288f
C38 PRE_ABSENT VPWR 0.40061f
C39 Q_ABSENT WL_ABSENT 0
C40 Q_PRESENT WL_PRESENT 0
C41 VPWR EN_ABSENT 0.01581f
C42 EN_PRESENT Q_PRESENT 0.00123f
C43 BL_PRESENT VPWR 0.98343f
C44 PRE_ABSENT Q_ABSENT 0
R0 VGND NMASK_ABSENT/S.n0 0.8005
R1 VGND NMASK_ABSENT/S.n0 0.20137
R2 NMASK_ABSENT/S.n0 VGND 0.00734783
R3 NMASK_ABSENT/S.t0 VGND 47.3272
R4 NROW_ABSENT/S NMASK_ABSENT/D.n0 0.00506522
R5 NMASK_ABSENT/D.n0 NROW_ABSENT/S 0.119196
R6 NROW_ABSENT/S NMASK_ABSENT/D.t0 47.3272
R7 EN_ABSENT NMASK_ABSENT/G.t0 244.714
R8 NMASK_ABSENT/B.t0 NMASK_ABSENT/B.n0 69.7099
R9 NMASK_ABSENT/B.n2 NMASK_ABSENT/B.n1 172.5
R10 NMASK_ABSENT/B.n4 NMASK_ABSENT/B.n3 86.2505
R11 NMASK_ABSENT/B.n5 NMASK_ABSENT/B.t0 172.5
R12 VGND NMASK_ABSENT/B.n5 172.5
R13 NMASK_ABSENT/B.n7 NMASK_ABSENT/B.n6 86.2505
R14 NMASK_ABSENT/B.n8 NMASK_ABSENT/B.n7 86.2505
R15 VGND NMASK_ABSENT/B.n6 417.921
R16 NMASK_ABSENT/B.n6 NMASK_ABSENT/B.t0 1245.88
R17 NMASK_ABSENT/B.n0 NMASK_ABSENT/B.n3 724.095
R18 VGND NMASK_ABSENT/B.n8 113.338
R19 VGND NMASK_ABSENT/B.n4 113.338
R20 NMASK_ABSENT/B.n8 NMASK_ABSENT/B.n2 113.338
R21 NMASK_ABSENT/B.n2 NMASK_ABSENT/B.n4 113.338
R22 NMASK_ABSENT/B.n7 NMASK_ABSENT/B.n5 1791.82
R23 NMASK_ABSENT/B.n5 NMASK_ABSENT/B.n3 1791.82
R24 NMASK_ABSENT/B.n7 NMASK_ABSENT/B.n1 1791.82
R25 NMASK_ABSENT/B.n1 NMASK_ABSENT/B.n0 93.7653
R26 VPWR PPRE_ABSENT/S.t0 139.071
R27 PPRE_ABSENT/D.n0 BL_ABSENT 0.809425
R28 BL_ABSENT PPRE_ABSENT/D.t0 139.071
R29 PRE_ABSENT PPRE_ABSENT/G.t0 257.373
R30 PPRE_ABSENT/B.n0 PPRE_ABSENT/B.n1 39.9246
R31 VPWR PPRE_ABSENT/B.n0 47.5005
R32 PPRE_ABSENT/B.n3 PPRE_ABSENT/B.n2 23.7505
R33 VPWR PPRE_ABSENT/B.n3 114.882
R34 PPRE_ABSENT/B.t0 PPRE_ABSENT/B.n4 5.97251
R35 PPRE_ABSENT/B.n5 PPRE_ABSENT/B.n6 47.5005
R36 PPRE_ABSENT/B.n3 PPRE_ABSENT/B.n6 114.882
R37 PPRE_ABSENT/B.n8 PPRE_ABSENT/B.n7 23.7505
R38 VPWR PPRE_ABSENT/B.n8 114.882
R39 PPRE_ABSENT/B.n8 PPRE_ABSENT/B.n6 114.882
R40 PPRE_ABSENT/B.n0 PPRE_ABSENT/B.n7 1181.65
R41 PPRE_ABSENT/B.n1 PPRE_ABSENT/B.n2 148.554
R42 PPRE_ABSENT/B.n2 PPRE_ABSENT/B.n5 1181.65
R43 PPRE_ABSENT/B.n4 PPRE_ABSENT/B.n5 39.9246
R44 PPRE_ABSENT/B.n1 PPRE_ABSENT/B.t0 5.97251
R45 PPRE_ABSENT/B.n4 PPRE_ABSENT/B.n7 148.554
R46 VPWR PSENSE_PRESENT/S.t0 139.071
R47 PSENSE_PRESENT/D.n0 Q_PRESENT 0.809425
R48 Q_PRESENT PSENSE_PRESENT/D.t0 139.071
R49 BL_PRESENT PSENSE_PRESENT/G.t0 257.373
R50 PSENSE_PRESENT/B.n0 PSENSE_PRESENT/B.n1 39.9246
R51 VPWR PSENSE_PRESENT/B.n0 47.5005
R52 PSENSE_PRESENT/B.n3 PSENSE_PRESENT/B.n2 23.7505
R53 VPWR PSENSE_PRESENT/B.n3 114.882
R54 PSENSE_PRESENT/B.t0 PSENSE_PRESENT/B.n4 5.97251
R55 PSENSE_PRESENT/B.n5 PSENSE_PRESENT/B.n6 47.5005
R56 PSENSE_PRESENT/B.n3 PSENSE_PRESENT/B.n6 114.882
R57 PSENSE_PRESENT/B.n8 PSENSE_PRESENT/B.n7 23.7505
R58 VPWR PSENSE_PRESENT/B.n8 114.882
R59 PSENSE_PRESENT/B.n8 PSENSE_PRESENT/B.n6 114.882
R60 PSENSE_PRESENT/B.n0 PSENSE_PRESENT/B.n7 1181.65
R61 PSENSE_PRESENT/B.n1 PSENSE_PRESENT/B.n2 148.554
R62 PSENSE_PRESENT/B.n2 PSENSE_PRESENT/B.n5 1181.65
R63 PSENSE_PRESENT/B.n4 PSENSE_PRESENT/B.n5 39.9246
R64 PSENSE_PRESENT/B.n1 PSENSE_PRESENT/B.t0 5.97251
R65 PSENSE_PRESENT/B.n4 PSENSE_PRESENT/B.n7 148.554
R66 NROW_PRESENT/S NROW_PRESENT/S.n0 0.8005
R67 NROW_PRESENT/S NROW_PRESENT/S.n0 0.20137
R68 NROW_PRESENT/S.n0 NROW_PRESENT/S 0.00734783
R69 NROW_PRESENT/S.t0 NROW_PRESENT/S 47.3272
R70 BL_PRESENT NROW_PRESENT/D.n0 0.00506522
R71 NROW_PRESENT/D.n0 BL_PRESENT 0.119196
R72 BL_PRESENT NROW_PRESENT/D.t0 47.3272
R73 WL_PRESENT NROW_PRESENT/G.t0 244.714
R74 NROW_PRESENT/B.t0 NROW_PRESENT/B.n0 69.7099
R75 NROW_PRESENT/B.n2 NROW_PRESENT/B.n1 172.5
R76 NROW_PRESENT/B.n4 NROW_PRESENT/B.n3 86.2505
R77 NROW_PRESENT/B.n5 NROW_PRESENT/B.t0 172.5
R78 VGND NROW_PRESENT/B.n5 172.5
R79 NROW_PRESENT/B.n7 NROW_PRESENT/B.n6 86.2505
R80 NROW_PRESENT/B.n8 NROW_PRESENT/B.n7 86.2505
R81 VGND NROW_PRESENT/B.n6 417.921
R82 NROW_PRESENT/B.n6 NROW_PRESENT/B.t0 1245.88
R83 NROW_PRESENT/B.n0 NROW_PRESENT/B.n3 724.095
R84 VGND NROW_PRESENT/B.n8 113.338
R85 VGND NROW_PRESENT/B.n4 113.338
R86 NROW_PRESENT/B.n8 NROW_PRESENT/B.n2 113.338
R87 NROW_PRESENT/B.n2 NROW_PRESENT/B.n4 113.338
R88 NROW_PRESENT/B.n7 NROW_PRESENT/B.n5 1791.82
R89 NROW_PRESENT/B.n5 NROW_PRESENT/B.n3 1791.82
R90 NROW_PRESENT/B.n7 NROW_PRESENT/B.n1 1791.82
R91 NROW_PRESENT/B.n1 NROW_PRESENT/B.n0 93.7653
R92 VPWR PPRE_PRESENT/S.t0 139.071
R93 PPRE_PRESENT/D.n0 BL_PRESENT 0.809425
R94 BL_PRESENT PPRE_PRESENT/D.t0 139.071
R95 PRE_PRESENT PPRE_PRESENT/G.t0 257.373
R96 PPRE_PRESENT/B.n0 PPRE_PRESENT/B.n1 39.9246
R97 VPWR PPRE_PRESENT/B.n0 47.5005
R98 PPRE_PRESENT/B.n3 PPRE_PRESENT/B.n2 23.7505
R99 VPWR PPRE_PRESENT/B.n3 114.882
R100 PPRE_PRESENT/B.t0 PPRE_PRESENT/B.n4 5.97251
R101 PPRE_PRESENT/B.n5 PPRE_PRESENT/B.n6 47.5005
R102 PPRE_PRESENT/B.n3 PPRE_PRESENT/B.n6 114.882
R103 PPRE_PRESENT/B.n8 PPRE_PRESENT/B.n7 23.7505
R104 VPWR PPRE_PRESENT/B.n8 114.882
R105 PPRE_PRESENT/B.n8 PPRE_PRESENT/B.n6 114.882
R106 PPRE_PRESENT/B.n0 PPRE_PRESENT/B.n7 1181.65
R107 PPRE_PRESENT/B.n1 PPRE_PRESENT/B.n2 148.554
R108 PPRE_PRESENT/B.n2 PPRE_PRESENT/B.n5 1181.65
R109 PPRE_PRESENT/B.n4 PPRE_PRESENT/B.n5 39.9246
R110 PPRE_PRESENT/B.n1 PPRE_PRESENT/B.t0 5.97251
R111 PPRE_PRESENT/B.n4 PPRE_PRESENT/B.n7 148.554
R112 VGND NSENSE_PRESENT/S.n0 0.8005
R113 VGND NSENSE_PRESENT/S.n0 0.20137
R114 NSENSE_PRESENT/S.n0 VGND 0.00734783
R115 NSENSE_PRESENT/S.t0 VGND 47.3272
R116 Q_PRESENT NSENSE_PRESENT/D.n0 0.00506522
R117 NSENSE_PRESENT/D.n0 Q_PRESENT 0.119196
R118 Q_PRESENT NSENSE_PRESENT/D.t0 47.3272
R119 BL_PRESENT NSENSE_PRESENT/G.t0 244.714
R120 NSENSE_PRESENT/B.t0 NSENSE_PRESENT/B.n0 69.7099
R121 NSENSE_PRESENT/B.n2 NSENSE_PRESENT/B.n1 172.5
R122 NSENSE_PRESENT/B.n4 NSENSE_PRESENT/B.n3 86.2505
R123 NSENSE_PRESENT/B.n5 NSENSE_PRESENT/B.t0 172.5
R124 VGND NSENSE_PRESENT/B.n5 172.5
R125 NSENSE_PRESENT/B.n7 NSENSE_PRESENT/B.n6 86.2505
R126 NSENSE_PRESENT/B.n8 NSENSE_PRESENT/B.n7 86.2505
R127 VGND NSENSE_PRESENT/B.n6 417.921
R128 NSENSE_PRESENT/B.n6 NSENSE_PRESENT/B.t0 1245.88
R129 NSENSE_PRESENT/B.n0 NSENSE_PRESENT/B.n3 724.095
R130 VGND NSENSE_PRESENT/B.n8 113.338
R131 VGND NSENSE_PRESENT/B.n4 113.338
R132 NSENSE_PRESENT/B.n8 NSENSE_PRESENT/B.n2 113.338
R133 NSENSE_PRESENT/B.n2 NSENSE_PRESENT/B.n4 113.338
R134 NSENSE_PRESENT/B.n7 NSENSE_PRESENT/B.n5 1791.82
R135 NSENSE_PRESENT/B.n5 NSENSE_PRESENT/B.n3 1791.82
R136 NSENSE_PRESENT/B.n7 NSENSE_PRESENT/B.n1 1791.82
R137 NSENSE_PRESENT/B.n1 NSENSE_PRESENT/B.n0 93.7653
R138 VPWR PSENSE_ABSENT/S.t0 139.071
R139 PSENSE_ABSENT/D.n0 Q_ABSENT 0.809425
R140 Q_ABSENT PSENSE_ABSENT/D.t0 139.071
R141 BL_ABSENT PSENSE_ABSENT/G.t0 257.373
R142 PSENSE_ABSENT/B.n0 PSENSE_ABSENT/B.n1 39.9246
R143 VPWR PSENSE_ABSENT/B.n0 47.5005
R144 PSENSE_ABSENT/B.n3 PSENSE_ABSENT/B.n2 23.7505
R145 VPWR PSENSE_ABSENT/B.n3 114.882
R146 PSENSE_ABSENT/B.t0 PSENSE_ABSENT/B.n4 5.97251
R147 PSENSE_ABSENT/B.n5 PSENSE_ABSENT/B.n6 47.5005
R148 PSENSE_ABSENT/B.n3 PSENSE_ABSENT/B.n6 114.882
R149 PSENSE_ABSENT/B.n8 PSENSE_ABSENT/B.n7 23.7505
R150 VPWR PSENSE_ABSENT/B.n8 114.882
R151 PSENSE_ABSENT/B.n8 PSENSE_ABSENT/B.n6 114.882
R152 PSENSE_ABSENT/B.n0 PSENSE_ABSENT/B.n7 1181.65
R153 PSENSE_ABSENT/B.n1 PSENSE_ABSENT/B.n2 148.554
R154 PSENSE_ABSENT/B.n2 PSENSE_ABSENT/B.n5 1181.65
R155 PSENSE_ABSENT/B.n4 PSENSE_ABSENT/B.n5 39.9246
R156 PSENSE_ABSENT/B.n1 PSENSE_ABSENT/B.t0 5.97251
R157 PSENSE_ABSENT/B.n4 PSENSE_ABSENT/B.n7 148.554
R158 VGND NSENSE_ABSENT/S.n0 0.8005
R159 VGND NSENSE_ABSENT/S.n0 0.20137
R160 NSENSE_ABSENT/S.n0 VGND 0.00734783
R161 NSENSE_ABSENT/S.t0 VGND 47.3272
R162 Q_ABSENT NSENSE_ABSENT/D.n0 0.00506522
R163 NSENSE_ABSENT/D.n0 Q_ABSENT 0.119196
R164 Q_ABSENT NSENSE_ABSENT/D.t0 47.3272
R165 BL_ABSENT NSENSE_ABSENT/G.t0 244.714
R166 NSENSE_ABSENT/B.t0 NSENSE_ABSENT/B.n0 69.7099
R167 NSENSE_ABSENT/B.n2 NSENSE_ABSENT/B.n1 172.5
R168 NSENSE_ABSENT/B.n4 NSENSE_ABSENT/B.n3 86.2505
R169 NSENSE_ABSENT/B.n5 NSENSE_ABSENT/B.t0 172.5
R170 VGND NSENSE_ABSENT/B.n5 172.5
R171 NSENSE_ABSENT/B.n7 NSENSE_ABSENT/B.n6 86.2505
R172 NSENSE_ABSENT/B.n8 NSENSE_ABSENT/B.n7 86.2505
R173 VGND NSENSE_ABSENT/B.n6 417.921
R174 NSENSE_ABSENT/B.n6 NSENSE_ABSENT/B.t0 1245.88
R175 NSENSE_ABSENT/B.n0 NSENSE_ABSENT/B.n3 724.095
R176 VGND NSENSE_ABSENT/B.n8 113.338
R177 VGND NSENSE_ABSENT/B.n4 113.338
R178 NSENSE_ABSENT/B.n8 NSENSE_ABSENT/B.n2 113.338
R179 NSENSE_ABSENT/B.n2 NSENSE_ABSENT/B.n4 113.338
R180 NSENSE_ABSENT/B.n7 NSENSE_ABSENT/B.n5 1791.82
R181 NSENSE_ABSENT/B.n5 NSENSE_ABSENT/B.n3 1791.82
R182 NSENSE_ABSENT/B.n7 NSENSE_ABSENT/B.n1 1791.82
R183 NSENSE_ABSENT/B.n1 NSENSE_ABSENT/B.n0 93.7653
R184 VGND NMASK_PRESENT/S.n0 0.8005
R185 VGND NMASK_PRESENT/S.n0 0.20137
R186 NMASK_PRESENT/S.n0 VGND 0.00734783
R187 NMASK_PRESENT/S.t0 VGND 47.3272
R188 NROW_PRESENT/S NMASK_PRESENT/D.n0 0.00506522
R189 NMASK_PRESENT/D.n0 NROW_PRESENT/S 0.119196
R190 NROW_PRESENT/S NMASK_PRESENT/D.t0 47.3272
R191 EN_PRESENT NMASK_PRESENT/G.t0 244.714
R192 NMASK_PRESENT/B.t0 NMASK_PRESENT/B.n0 69.7099
R193 NMASK_PRESENT/B.n2 NMASK_PRESENT/B.n1 172.5
R194 NMASK_PRESENT/B.n4 NMASK_PRESENT/B.n3 86.2505
R195 NMASK_PRESENT/B.n5 NMASK_PRESENT/B.t0 172.5
R196 VGND NMASK_PRESENT/B.n5 172.5
R197 NMASK_PRESENT/B.n7 NMASK_PRESENT/B.n6 86.2505
R198 NMASK_PRESENT/B.n8 NMASK_PRESENT/B.n7 86.2505
R199 VGND NMASK_PRESENT/B.n6 417.921
R200 NMASK_PRESENT/B.n6 NMASK_PRESENT/B.t0 1245.88
R201 NMASK_PRESENT/B.n0 NMASK_PRESENT/B.n3 724.095
R202 VGND NMASK_PRESENT/B.n8 113.338
R203 VGND NMASK_PRESENT/B.n4 113.338
R204 NMASK_PRESENT/B.n8 NMASK_PRESENT/B.n2 113.338
R205 NMASK_PRESENT/B.n2 NMASK_PRESENT/B.n4 113.338
R206 NMASK_PRESENT/B.n7 NMASK_PRESENT/B.n5 1791.82
R207 NMASK_PRESENT/B.n5 NMASK_PRESENT/B.n3 1791.82
R208 NMASK_PRESENT/B.n7 NMASK_PRESENT/B.n1 1791.82
R209 NMASK_PRESENT/B.n1 NMASK_PRESENT/B.n0 93.7653
R210 NROW_ABSENT/S NROW_ABSENT/S.n0 0.8005
R211 NROW_ABSENT/S NROW_ABSENT/S.n0 0.20137
R212 NROW_ABSENT/S.n0 NROW_ABSENT/S 0.00734783
R213 NROW_ABSENT/S.t0 NROW_ABSENT/S 47.3272
R214 ROM_DRAIN_ABSENT NROW_ABSENT/D.n0 0.00506522
R215 NROW_ABSENT/D.n0 ROM_DRAIN_ABSENT 0.119196
R216 ROM_DRAIN_ABSENT NROW_ABSENT/D.t0 47.3272
R217 WL_ABSENT NROW_ABSENT/G.t0 244.714
R218 NROW_ABSENT/B.t0 NROW_ABSENT/B.n0 69.7099
R219 NROW_ABSENT/B.n2 NROW_ABSENT/B.n1 172.5
R220 NROW_ABSENT/B.n4 NROW_ABSENT/B.n3 86.2505
R221 NROW_ABSENT/B.n5 NROW_ABSENT/B.t0 172.5
R222 VGND NROW_ABSENT/B.n5 172.5
R223 NROW_ABSENT/B.n7 NROW_ABSENT/B.n6 86.2505
R224 NROW_ABSENT/B.n8 NROW_ABSENT/B.n7 86.2505
R225 VGND NROW_ABSENT/B.n6 417.921
R226 NROW_ABSENT/B.n6 NROW_ABSENT/B.t0 1245.88
R227 NROW_ABSENT/B.n0 NROW_ABSENT/B.n3 724.095
R228 VGND NROW_ABSENT/B.n8 113.338
R229 VGND NROW_ABSENT/B.n4 113.338
R230 NROW_ABSENT/B.n8 NROW_ABSENT/B.n2 113.338
R231 NROW_ABSENT/B.n2 NROW_ABSENT/B.n4 113.338
R232 NROW_ABSENT/B.n7 NROW_ABSENT/B.n5 1791.82
R233 NROW_ABSENT/B.n5 NROW_ABSENT/B.n3 1791.82
R234 NROW_ABSENT/B.n7 NROW_ABSENT/B.n1 1791.82
R235 NROW_ABSENT/B.n1 NROW_ABSENT/B.n0 93.7653
R236 VGND.n1 VGND.n0 0.4005
R237 VGND.n3 VGND.n2 0.4005
R238 VGND.n5 VGND.n4 0.4005
R239 VGND.n7 VGND.n6 0.4005
R240 VGND.n9 VGND.n8 0.4005
R241 VGND.n72 VGND.n10 0.4005
R242 VGND VGND.n1 0.308937
R243 VGND.n1 VGND.n3 1.7505
R244 VGND.n3 VGND.n75 0.09675
R245 VGND.n75 VGND.n5 1.65425
R246 VGND.n5 VGND.n74 0.09675
R247 VGND.n74 VGND.n7 4.27925
R248 VGND.n7 VGND.n9 1.7505
R249 VGND.n9 VGND.n73 0.09675
R250 VGND.n73 VGND.n72 1.65425
R251 VGND.n75 VGND 0.197323
R252 VGND.n74 VGND 0.197323
R253 VGND.n73 VGND 0.197323
R254 VGND.n72 VGND 0.293573
R255 VGND.n12 VGND.n11 172.5
R256 VGND.n10 VGND.n12 172.5
R257 VGND VGND.n10 0.309324
R258 VGND.n14 VGND.n13 86.2505
R259 VGND.n15 VGND.n14 86.2505
R260 VGND VGND.n15 113.029
R261 VGND.n11 VGND.n16 172.5
R262 VGND.n17 VGND.n16 172.5
R263 VGND.n17 VGND.n15 113.338
R264 VGND.n70 VGND.n69 86.2505
R265 VGND.n71 VGND.n70 86.2505
R266 VGND.n10 VGND.n71 113.338
R267 VGND.n71 VGND.n17 113.338
R268 VGND.n12 VGND.n70 1791.82
R269 VGND.n12 VGND.n14 1791.82
R270 VGND.n14 VGND.n16 1791.82
R271 VGND.n16 VGND.n70 1791.82
R272 VGND.n18 VGND.n19 172.5
R273 VGND.n20 VGND.n19 172.5
R274 VGND.n22 VGND.n21 86.2505
R275 VGND.n23 VGND.n22 86.2505
R276 VGND.n24 VGND.n18 172.5
R277 VGND.n6 VGND.n24 172.5
R278 VGND.n26 VGND.n25 86.2505
R279 VGND.n27 VGND.n26 86.2505
R280 VGND.n28 VGND.n29 172.5
R281 VGND.n30 VGND.n29 172.5
R282 VGND.n32 VGND.n31 86.2505
R283 VGND.n33 VGND.n32 86.2505
R284 VGND.n34 VGND.n28 172.5
R285 VGND.n8 VGND.n34 172.5
R286 VGND.n36 VGND.n35 86.2505
R287 VGND.n37 VGND.n36 86.2505
R288 VGND VGND.n25 150.744
R289 VGND.n25 VGND.n18 449.387
R290 VGND.n18 VGND.n21 449.387
R291 VGND.n21 VGND 1225.86
R292 VGND VGND.n35 150.744
R293 VGND.n35 VGND.n28 449.387
R294 VGND.n28 VGND.n31 449.387
R295 VGND.n31 VGND 1225.86
R296 VGND VGND.n13 150.744
R297 VGND.n13 VGND.n11 449.387
R298 VGND.n11 VGND.n69 449.387
R299 VGND.n68 VGND 3018.78
R300 VGND.n38 VGND.n39 172.5
R301 VGND.n40 VGND.n39 172.5
R302 VGND.n42 VGND.n41 86.2505
R303 VGND.n43 VGND.n42 86.2505
R304 VGND.n44 VGND.n38 172.5
R305 VGND.n0 VGND.n44 172.5
R306 VGND.n46 VGND.n45 86.2505
R307 VGND.n47 VGND.n46 86.2505
R308 VGND.n48 VGND.n49 172.5
R309 VGND.n50 VGND.n49 172.5
R310 VGND.n52 VGND.n51 86.2505
R311 VGND.n53 VGND.n52 86.2505
R312 VGND.n54 VGND.n48 172.5
R313 VGND.n2 VGND.n54 172.5
R314 VGND.n56 VGND.n55 86.2505
R315 VGND.n57 VGND.n56 86.2505
R316 VGND.n58 VGND.n59 172.5
R317 VGND.n60 VGND.n59 172.5
R318 VGND.n62 VGND.n61 86.2505
R319 VGND.n63 VGND.n62 86.2505
R320 VGND.n64 VGND.n58 172.5
R321 VGND.n4 VGND.n64 172.5
R322 VGND.n66 VGND.n65 86.2505
R323 VGND.n67 VGND.n66 86.2505
R324 VGND VGND.n45 150.744
R325 VGND.n45 VGND.n38 449.387
R326 VGND.n38 VGND.n41 449.387
R327 VGND.n41 VGND 1225.86
R328 VGND VGND.n55 150.744
R329 VGND.n55 VGND.n48 449.387
R330 VGND.n48 VGND.n51 449.387
R331 VGND.n51 VGND 1225.86
R332 VGND VGND.n65 150.744
R333 VGND.n65 VGND.n58 449.387
R334 VGND.n58 VGND.n61 449.387
R335 VGND.n61 VGND.n68 150.744
R336 VGND VGND.n48 22342.2
R337 VGND.n48 VGND.n68 13478.5
R338 VGND.n67 VGND 113.029
R339 VGND VGND.n4 0.309324
R340 VGND.n4 VGND.n63 113.338
R341 VGND.n60 VGND.n67 113.338
R342 VGND.n63 VGND.n60 113.338
R343 VGND.n66 VGND.n64 1791.82
R344 VGND.n64 VGND.n62 1791.82
R345 VGND.n66 VGND.n59 1791.82
R346 VGND.n59 VGND.n62 1791.82
R347 VGND.n57 VGND 113.029
R348 VGND VGND.n2 0.309324
R349 VGND.n2 VGND.n53 113.338
R350 VGND.n50 VGND.n57 113.338
R351 VGND.n53 VGND.n50 113.338
R352 VGND.n56 VGND.n54 1791.82
R353 VGND.n54 VGND.n52 1791.82
R354 VGND.n56 VGND.n49 1791.82
R355 VGND.n49 VGND.n52 1791.82
R356 VGND.n47 VGND 113.029
R357 VGND VGND.n0 0.309324
R358 VGND.n0 VGND.n43 113.338
R359 VGND.n40 VGND.n47 113.338
R360 VGND.n43 VGND.n40 113.338
R361 VGND.n46 VGND.n44 1791.82
R362 VGND.n44 VGND.n42 1791.82
R363 VGND.n46 VGND.n39 1791.82
R364 VGND.n39 VGND.n42 1791.82
R365 VGND VGND.n28 13478.5
R366 VGND.n69 VGND.n28 19851.8
R367 VGND.n37 VGND 113.029
R368 VGND VGND.n8 0.309324
R369 VGND.n8 VGND.n33 113.338
R370 VGND.n30 VGND.n37 113.338
R371 VGND.n33 VGND.n30 113.338
R372 VGND.n36 VGND.n34 1791.82
R373 VGND.n34 VGND.n32 1791.82
R374 VGND.n36 VGND.n29 1791.82
R375 VGND.n29 VGND.n32 1791.82
R376 VGND.n27 VGND 113.029
R377 VGND VGND.n6 0.309324
R378 VGND.n6 VGND.n23 113.338
R379 VGND.n20 VGND.n27 113.338
R380 VGND.n23 VGND.n20 113.338
R381 VGND.n26 VGND.n24 1791.82
R382 VGND.n24 VGND.n22 1791.82
R383 VGND.n26 VGND.n19 1791.82
R384 VGND.n19 VGND.n22 1791.82
R385 Q_ABSENT.n0 Q_ABSENT 0.0765
R386 Q_ABSENT Q_ABSENT.n0 1.20419
R387 Q_ABSENT Q_ABSENT.n0 0.54925
R388 Q_PRESENT.n0 Q_PRESENT 0.0765
R389 Q_PRESENT Q_PRESENT.n0 1.20419
R390 Q_PRESENT Q_PRESENT.n0 0.54925
R391 VPWR.n10 VPWR.n0 0.4005
R392 VPWR.n11 VPWR.n21 0.4005
R393 VPWR.n22 VPWR.n32 0.4005
R394 VPWR.n33 VPWR.n43 0.4005
R395 VPWR VPWR.n10 0.308937
R396 VPWR.n10 VPWR.n46 0.09675
R397 VPWR.n46 VPWR 3.09581
R398 VPWR VPWR.n21 0.308937
R399 VPWR.n21 VPWR.n45 0.09675
R400 VPWR.n45 VPWR 3.97081
R401 VPWR VPWR.n32 0.308937
R402 VPWR.n32 VPWR.n44 0.09675
R403 VPWR.n44 VPWR 3.09581
R404 VPWR VPWR.n43 0.308937
R405 VPWR.n46 VPWR 0.197323
R406 VPWR.n45 VPWR 0.197323
R407 VPWR.n44 VPWR 0.197323
R408 VPWR.n43 VPWR 0.293573
R409 VPWR.n35 VPWR.n33 47.5005
R410 VPWR.n38 VPWR.n36 18.0607
R411 VPWR.n36 VPWR.n37 23.7505
R412 VPWR.n33 VPWR.n37 114.882
R413 VPWR.n39 VPWR.n40 47.5005
R414 VPWR.n37 VPWR.n40 114.882
R415 VPWR.n34 VPWR.n41 18.0607
R416 VPWR.n41 VPWR.n42 23.7505
R417 VPWR.n33 VPWR.n42 114.882
R418 VPWR.n42 VPWR.n40 114.882
R419 VPWR.n35 VPWR.n34 265.053
R420 VPWR.n35 VPWR.n36 1181.65
R421 VPWR.n38 VPWR.n39 265.053
R422 VPWR.n39 VPWR.n41 1181.65
R423 VPWR.n34 VPWR.n38 10.6561
R424 VPWR.n24 VPWR.n22 47.5005
R425 VPWR.n27 VPWR.n25 18.0607
R426 VPWR.n25 VPWR.n26 23.7505
R427 VPWR.n22 VPWR.n26 114.882
R428 VPWR.n28 VPWR.n29 47.5005
R429 VPWR.n26 VPWR.n29 114.882
R430 VPWR.n23 VPWR.n30 18.0607
R431 VPWR.n30 VPWR.n31 23.7505
R432 VPWR.n22 VPWR.n31 114.882
R433 VPWR.n31 VPWR.n29 114.882
R434 VPWR.n24 VPWR.n23 265.053
R435 VPWR.n24 VPWR.n25 1181.65
R436 VPWR.n27 VPWR.n28 265.053
R437 VPWR.n28 VPWR.n30 1181.65
R438 VPWR.n23 VPWR.n27 10.6561
R439 VPWR.n13 VPWR.n11 47.5005
R440 VPWR.n16 VPWR.n14 18.0607
R441 VPWR.n14 VPWR.n15 23.7505
R442 VPWR.n11 VPWR.n15 114.882
R443 VPWR.n17 VPWR.n18 47.5005
R444 VPWR.n15 VPWR.n18 114.882
R445 VPWR.n12 VPWR.n19 18.0607
R446 VPWR.n19 VPWR.n20 23.7505
R447 VPWR.n11 VPWR.n20 114.882
R448 VPWR.n20 VPWR.n18 114.882
R449 VPWR.n13 VPWR.n12 265.053
R450 VPWR.n13 VPWR.n14 1181.65
R451 VPWR.n16 VPWR.n17 265.053
R452 VPWR.n17 VPWR.n19 1181.65
R453 VPWR.n12 VPWR.n16 10.6561
R454 VPWR.n0 VPWR.n2 47.5005
R455 VPWR.n3 VPWR.n5 18.0607
R456 VPWR.n4 VPWR.n3 23.7505
R457 VPWR.n0 VPWR.n4 114.882
R458 VPWR.n7 VPWR.n6 47.5005
R459 VPWR.n4 VPWR.n7 114.882
R460 VPWR.n8 VPWR.n1 18.0607
R461 VPWR.n9 VPWR.n8 23.7505
R462 VPWR.n0 VPWR.n9 114.882
R463 VPWR.n9 VPWR.n7 114.882
R464 VPWR.n2 VPWR.n1 265.053
R465 VPWR.n2 VPWR.n3 1181.65
R466 VPWR.n5 VPWR.n6 265.053
R467 VPWR.n6 VPWR.n8 1181.65
R468 VPWR.n1 VPWR.n5 10.6561
R469 NROW_ABSENT/S m1_4190_598.n0 0.0222241
R470 NROW_ABSENT/S m1_4190_598.n0 1.25869
R471 NROW_ABSENT/S m1_4190_598.n0 0.807348
R472 NROW_PRESENT/S m1_590_598.n0 0.0222241
R473 NROW_PRESENT/S m1_590_598.n0 1.25869
R474 NROW_PRESENT/S m1_590_598.n0 0.807348
R475 BL_ABSENT.n0 BL_ABSENT.n1 2.03842
R476 BL_ABSENT BL_ABSENT.n1 0.046
R477 BL_ABSENT.n1 BL_ABSENT 3.08225
R478 BL_ABSENT BL_ABSENT.n0 0.823326
R479 BL_PRESENT BL_PRESENT.n0 0.0312759
R480 BL_PRESENT.n2 BL_PRESENT.n0 2.21925
R481 BL_PRESENT BL_PRESENT.n2 2.84775
R482 BL_PRESENT.n2 BL_PRESENT 0.78625
R483 BL_PRESENT BL_PRESENT.n1 0.046
R484 BL_PRESENT.n1 BL_PRESENT 3.08225
R485 BL_PRESENT BL_PRESENT.n1 2.86124
R486 BL_PRESENT BL_PRESENT.n0 0.807348
R487 w_0_0.n0 w_0_0.n1 172.5
R488 w_0_0.n2 w_0_0.n1 172.5
R489 w_0_0.n3 w_0_0.n4 86.2505
R490 w_0_0.n4 w_0_0.n5 86.2505
R491 w_0_0.n0 w_0_0.n6 172.5
R492 w_0_0.n6 VGND 172.5
R493 w_0_0.n8 w_0_0.n7 86.2505
R494 w_0_0.n9 w_0_0.n8 86.2505
R495 w_0_0.n10 w_0_0.n11 172.5
R496 w_0_0.n12 w_0_0.n11 172.5
R497 w_0_0.n14 w_0_0.n13 86.2505
R498 w_0_0.n15 w_0_0.n14 86.2505
R499 w_0_0.n10 w_0_0.n16 172.5
R500 w_0_0.n16 VGND 172.5
R501 w_0_0.n17 w_0_0.n18 86.2505
R502 w_0_0.n18 w_0_0.n19 86.2505
R503 w_0_0.n20 w_0_0.n21 172.5
R504 w_0_0.n22 w_0_0.n21 172.5
R505 w_0_0.n23 w_0_0.n24 86.2505
R506 w_0_0.n24 w_0_0.n25 86.2505
R507 w_0_0.n20 w_0_0.n26 172.5
R508 w_0_0.n26 VGND 172.5
R509 w_0_0.n28 w_0_0.n27 86.2505
R510 w_0_0.n29 w_0_0.n28 86.2505
R511 VGND w_0_0.n7 150.744
R512 w_0_0.n7 w_0_0.n0 449.387
R513 w_0_0.n3 w_0_0.n0 449.387
R514 VGND w_0_0.n3 1225.86
R515 VGND w_0_0.n17 150.744
R516 w_0_0.n17 w_0_0.n10 449.387
R517 w_0_0.n10 w_0_0.n13 449.387
R518 w_0_0.n13 VGND 1225.86
R519 VGND w_0_0.n27 150.744
R520 w_0_0.n27 w_0_0.n20 449.387
R521 w_0_0.n23 w_0_0.n20 449.387
R522 w_0_0.n30 w_0_0.n23 150.744
R523 VGND w_0_0.n10 22342.2
R524 w_0_0.n10 w_0_0.n30 13478.5
R525 w_0_0.n30 VGND 3018.78
R526 w_0_0.n31 w_0_0.n32 172.5
R527 w_0_0.n32 w_0_0.n33 172.5
R528 w_0_0.n34 w_0_0.n35 86.2505
R529 w_0_0.n35 w_0_0.n36 86.2505
R530 w_0_0.n31 w_0_0.n37 172.5
R531 w_0_0.n37 VGND 172.5
R532 w_0_0.n38 w_0_0.n39 86.2505
R533 w_0_0.n39 w_0_0.n40 86.2505
R534 w_0_0.n41 w_0_0.n42 172.5
R535 w_0_0.n42 w_0_0.n43 172.5
R536 w_0_0.n44 w_0_0.n45 86.2505
R537 w_0_0.n45 w_0_0.n46 86.2505
R538 w_0_0.n41 w_0_0.n47 172.5
R539 w_0_0.n47 VGND 172.5
R540 w_0_0.n48 w_0_0.n49 86.2505
R541 w_0_0.n49 w_0_0.n50 86.2505
R542 w_0_0.n51 w_0_0.n52 172.5
R543 w_0_0.n52 w_0_0.n53 172.5
R544 w_0_0.n54 w_0_0.n55 86.2505
R545 w_0_0.n55 w_0_0.n56 86.2505
R546 w_0_0.n51 w_0_0.n57 172.5
R547 w_0_0.n57 VGND 172.5
R548 w_0_0.n58 w_0_0.n59 86.2505
R549 w_0_0.n59 w_0_0.n69 86.2505
R550 VGND w_0_0.n38 150.744
R551 w_0_0.n38 w_0_0.n31 449.387
R552 w_0_0.n31 w_0_0.n34 449.387
R553 w_0_0.n34 VGND 1225.86
R554 VGND w_0_0.n48 150.744
R555 w_0_0.n48 w_0_0.n41 449.387
R556 w_0_0.n41 w_0_0.n44 449.387
R557 w_0_0.n44 VGND 1225.86
R558 VGND w_0_0.n58 150.744
R559 w_0_0.n58 w_0_0.n51 449.387
R560 w_0_0.n51 w_0_0.n54 449.387
R561 VGND w_0_0.n41 13478.5
R562 w_0_0.n54 w_0_0.n41 19851.8
R563 VGND w_0_0.n68 0.4005
R564 w_0_0.n69 VGND 113.338
R565 VGND w_0_0.n56 113.338
R566 w_0_0.n69 w_0_0.n53 113.338
R567 w_0_0.n53 w_0_0.n56 113.338
R568 VGND w_0_0.n60 0.4005
R569 VGND w_0_0.n61 0.4005
R570 VGND w_0_0.n62 0.4005
R571 VGND w_0_0.n63 0.4005
R572 VGND w_0_0.n64 0.4005
R573 VGND w_0_0.n60 0.308937
R574 w_0_0.n60 w_0_0.n61 1.7505
R575 w_0_0.n61 w_0_0.n67 0.09675
R576 w_0_0.n67 w_0_0.n62 1.65425
R577 w_0_0.n62 w_0_0.n66 0.09675
R578 w_0_0.n66 w_0_0.n63 4.27925
R579 w_0_0.n63 w_0_0.n64 1.7505
R580 w_0_0.n64 w_0_0.n65 0.09675
R581 w_0_0.n65 w_0_0.n68 1.65425
R582 w_0_0.n67 VGND 0.197323
R583 w_0_0.n66 VGND 0.197323
R584 w_0_0.n65 VGND 0.197323
R585 w_0_0.n68 VGND 0.293573
R586 VGND w_0_0.n50 113.338
R587 w_0_0.n50 w_0_0.n43 113.338
R588 VGND w_0_0.n46 113.338
R589 w_0_0.n46 w_0_0.n43 113.338
R590 VGND w_0_0.n40 113.338
R591 w_0_0.n40 w_0_0.n33 113.338
R592 VGND w_0_0.n36 113.338
R593 w_0_0.n36 w_0_0.n33 113.338
R594 VGND w_0_0.n29 113.338
R595 w_0_0.n22 w_0_0.n29 113.338
R596 VGND w_0_0.n25 113.338
R597 w_0_0.n25 w_0_0.n22 113.338
R598 VGND w_0_0.n19 113.338
R599 w_0_0.n19 w_0_0.n12 113.338
R600 VGND w_0_0.n15 113.338
R601 w_0_0.n12 w_0_0.n15 113.338
R602 VGND w_0_0.n9 113.338
R603 w_0_0.n2 w_0_0.n9 113.338
R604 VGND w_0_0.n5 113.338
R605 w_0_0.n5 w_0_0.n2 113.338
R606 w_0_0.n59 w_0_0.n57 1791.82
R607 w_0_0.n57 w_0_0.n55 1791.82
R608 w_0_0.n59 w_0_0.n52 1791.82
R609 w_0_0.n52 w_0_0.n55 1791.82
R610 w_0_0.n49 w_0_0.n47 1791.82
R611 w_0_0.n47 w_0_0.n45 1791.82
R612 w_0_0.n49 w_0_0.n42 1791.82
R613 w_0_0.n42 w_0_0.n45 1791.82
R614 w_0_0.n39 w_0_0.n37 1791.82
R615 w_0_0.n37 w_0_0.n35 1791.82
R616 w_0_0.n39 w_0_0.n32 1791.82
R617 w_0_0.n32 w_0_0.n35 1791.82
R618 w_0_0.n28 w_0_0.n26 1791.82
R619 w_0_0.n26 w_0_0.n24 1791.82
R620 w_0_0.n28 w_0_0.n21 1791.82
R621 w_0_0.n21 w_0_0.n24 1791.82
R622 w_0_0.n18 w_0_0.n16 1791.82
R623 w_0_0.n16 w_0_0.n14 1791.82
R624 w_0_0.n18 w_0_0.n11 1791.82
R625 w_0_0.n11 w_0_0.n14 1791.82
R626 w_0_0.n8 w_0_0.n6 1791.82
R627 w_0_0.n6 w_0_0.n4 1791.82
R628 w_0_0.n8 w_0_0.n1 1791.82
R629 w_0_0.n1 w_0_0.n4 1791.82
C45 BL_PRESENT.n0 VGND 0.02559f ; **FLOATING
C46 BL_PRESENT.n1 VGND 0.15588f ; **FLOATING
C47 BL_PRESENT.n2 VGND 0.19457f ; **FLOATING
C48 BL_ABSENT.n0 VGND 0.0292f ; **FLOATING
C49 BL_ABSENT.n1 VGND 0.1572f ; **FLOATING
C50 m1_590_598.n0 VGND 0.08492f ; **FLOATING
C51 m1_4190_598.n0 VGND 0.08425f ; **FLOATING
C52 VPWR.n0 VGND 0.00788f ; **FLOATING
C53 VPWR.n1 VGND 0.03459f ; **FLOATING
C54 VPWR.n2 VGND 0.04424f ; **FLOATING
C55 VPWR.n3 VGND 0.00778f ; **FLOATING
C56 VPWR.n4 VGND 0.00778f ; **FLOATING
C57 VPWR.n5 VGND 0.03459f ; **FLOATING
C58 VPWR.n6 VGND 0.04424f ; **FLOATING
C59 VPWR.n7 VGND 0.00788f ; **FLOATING
C60 VPWR.n8 VGND 0.00778f ; **FLOATING
C61 VPWR.n9 VGND 0.00778f ; **FLOATING
C62 VPWR.n10 VGND 0.00263f ; **FLOATING
C63 VPWR.n11 VGND 0.00788f ; **FLOATING
C64 VPWR.n12 VGND 0.03459f ; **FLOATING
C65 VPWR.n13 VGND 0.04424f ; **FLOATING
C66 VPWR.n14 VGND 0.00778f ; **FLOATING
C67 VPWR.n15 VGND 0.00778f ; **FLOATING
C68 VPWR.n16 VGND 0.03459f ; **FLOATING
C69 VPWR.n17 VGND 0.04424f ; **FLOATING
C70 VPWR.n18 VGND 0.00788f ; **FLOATING
C71 VPWR.n19 VGND 0.00778f ; **FLOATING
C72 VPWR.n20 VGND 0.00778f ; **FLOATING
C73 VPWR.n21 VGND 0.00263f ; **FLOATING
C74 VPWR.n22 VGND 0.00788f ; **FLOATING
C75 VPWR.n23 VGND 0.03459f ; **FLOATING
C76 VPWR.n24 VGND 0.04424f ; **FLOATING
C77 VPWR.n25 VGND 0.00778f ; **FLOATING
C78 VPWR.n26 VGND 0.00778f ; **FLOATING
C79 VPWR.n27 VGND 0.03459f ; **FLOATING
C80 VPWR.n28 VGND 0.04424f ; **FLOATING
C81 VPWR.n29 VGND 0.00788f ; **FLOATING
C82 VPWR.n30 VGND 0.00778f ; **FLOATING
C83 VPWR.n31 VGND 0.00778f ; **FLOATING
C84 VPWR.n32 VGND 0.00263f ; **FLOATING
C85 VPWR.n33 VGND 0.00788f ; **FLOATING
C86 VPWR.n34 VGND 0.03459f ; **FLOATING
C87 VPWR.n35 VGND 0.04424f ; **FLOATING
C88 VPWR.n36 VGND 0.00778f ; **FLOATING
C89 VPWR.n37 VGND 0.00778f ; **FLOATING
C90 VPWR.n38 VGND 0.03459f ; **FLOATING
C91 VPWR.n39 VGND 0.04424f ; **FLOATING
C92 VPWR.n40 VGND 0.00788f ; **FLOATING
C93 VPWR.n41 VGND 0.00778f ; **FLOATING
C94 VPWR.n42 VGND 0.00778f ; **FLOATING
C95 VPWR.n43 VGND 0.01442f ; **FLOATING
C96 VPWR.n44 VGND 0.0218f ; **FLOATING
C97 VPWR.n45 VGND 0.02749f ; **FLOATING
C98 VPWR.n46 VGND 0.0218f ; **FLOATING
C99 Q_PRESENT.n0 VGND 0.1541f ; **FLOATING
C100 Q_ABSENT.n0 VGND 0.15323f ; **FLOATING
C101 VGND.n0 VGND 0 ; **FLOATING
C102 VGND.n1 VGND 0.00124f ; **FLOATING
C103 VGND.n2 VGND 0 ; **FLOATING
C104 VGND.n3 VGND 0.00111f ; **FLOATING
C105 VGND.n4 VGND 0 ; **FLOATING
C106 VGND.n5 VGND 0.00105f ; **FLOATING
C107 VGND.n6 VGND 0 ; **FLOATING
C108 VGND.n7 VGND 0.00363f ; **FLOATING
C109 VGND.n8 VGND 0 ; **FLOATING
C110 VGND.n9 VGND 0.00111f ; **FLOATING
C111 VGND.n10 VGND 0 ; **FLOATING
C112 VGND.n11 VGND 0.01342f ; **FLOATING
C113 VGND.n12 VGND 0 ; **FLOATING
C114 VGND.n13 VGND 0.00896f ; **FLOATING
C115 VGND.n14 VGND 0 ; **FLOATING
C116 VGND.n15 VGND 0 ; **FLOATING
C117 VGND.n16 VGND 0 ; **FLOATING
C118 VGND.n17 VGND 0 ; **FLOATING
C119 VGND.n18 VGND 0.01342f ; **FLOATING
C120 VGND.n19 VGND 0 ; **FLOATING
C121 VGND.n20 VGND 0 ; **FLOATING
C122 VGND.n21 VGND 0.02501f ; **FLOATING
C123 VGND.n22 VGND 0 ; **FLOATING
C124 VGND.n23 VGND 0 ; **FLOATING
C125 VGND.n24 VGND 0 ; **FLOATING
C126 VGND.n25 VGND 0.00896f ; **FLOATING
C127 VGND.n26 VGND 0 ; **FLOATING
C128 VGND.n27 VGND 0 ; **FLOATING
C129 VGND.n28 VGND 0.067f ; **FLOATING
C130 VGND.n29 VGND 0 ; **FLOATING
C131 VGND.n30 VGND 0 ; **FLOATING
C132 VGND.n31 VGND 0.02501f ; **FLOATING
C133 VGND.n32 VGND 0 ; **FLOATING
C134 VGND.n33 VGND 0 ; **FLOATING
C135 VGND.n34 VGND 0 ; **FLOATING
C136 VGND.n35 VGND 0.00896f ; **FLOATING
C137 VGND.n36 VGND 0 ; **FLOATING
C138 VGND.n37 VGND 0 ; **FLOATING
C139 VGND.n38 VGND 0.01342f ; **FLOATING
C140 VGND.n39 VGND 0 ; **FLOATING
C141 VGND.n40 VGND 0 ; **FLOATING
C142 VGND.n41 VGND 0.02501f ; **FLOATING
C143 VGND.n42 VGND 0 ; **FLOATING
C144 VGND.n43 VGND 0 ; **FLOATING
C145 VGND.n44 VGND 0 ; **FLOATING
C146 VGND.n45 VGND 0.00896f ; **FLOATING
C147 VGND.n46 VGND 0 ; **FLOATING
C148 VGND.n47 VGND 0 ; **FLOATING
C149 VGND.n48 VGND 0.06522f ; **FLOATING
C150 VGND.n49 VGND 0 ; **FLOATING
C151 VGND.n50 VGND 0 ; **FLOATING
C152 VGND.n51 VGND 0.02501f ; **FLOATING
C153 VGND.n52 VGND 0 ; **FLOATING
C154 VGND.n53 VGND 0 ; **FLOATING
C155 VGND.n54 VGND 0 ; **FLOATING
C156 VGND.n55 VGND 0.00896f ; **FLOATING
C157 VGND.n56 VGND 0 ; **FLOATING
C158 VGND.n57 VGND 0 ; **FLOATING
C159 VGND.n58 VGND 0.01342f ; **FLOATING
C160 VGND.n59 VGND 0 ; **FLOATING
C161 VGND.n60 VGND 0 ; **FLOATING
C162 VGND.n61 VGND 0.00896f ; **FLOATING
C163 VGND.n62 VGND 0 ; **FLOATING
C164 VGND.n63 VGND 0 ; **FLOATING
C165 VGND.n64 VGND 0 ; **FLOATING
C166 VGND.n65 VGND 0.00896f ; **FLOATING
C167 VGND.n66 VGND 0 ; **FLOATING
C168 VGND.n67 VGND 0 ; **FLOATING
C169 VGND.n68 VGND 0.10769f ; **FLOATING
C170 VGND.n69 VGND 0.07616f ; **FLOATING
C171 VGND.n70 VGND 0 ; **FLOATING
C172 VGND.n71 VGND 0 ; **FLOATING
C173 VGND.n72 VGND 0.00215f ; **FLOATING
C174 VGND.n73 VGND 0.00115f ; **FLOATING
C175 VGND.n74 VGND 0.00274f ; **FLOATING
C176 VGND.n75 VGND 0.00115f ; **FLOATING
C177 NROW_ABSENT/S VGND 1.40812f
C178 ROM_DRAIN_ABSENT VGND 0.30962f
C179 WL_ABSENT VGND 0.79956f
C180 NROW_ABSENT/G.t0 VGND 0.0339f ; **FLOATING
C181 NROW_ABSENT/D.n0 VGND 0.01002f ; **FLOATING
C182 NROW_ABSENT/D.t0 VGND 0.07034f ; **FLOATING
C183 NROW_ABSENT/S.t0 VGND 0.07034f ; **FLOATING
C184 NROW_ABSENT/S.n0 VGND 0.01688f ; **FLOATING
C185 EN_PRESENT VGND 0.82465f
C186 NMASK_PRESENT/G.t0 VGND 0.0339f ; **FLOATING
C187 NMASK_PRESENT/D.n0 VGND 0.01002f ; **FLOATING
C188 NMASK_PRESENT/D.t0 VGND 0.07034f ; **FLOATING
C189 NMASK_PRESENT/S.t0 VGND 0.07034f ; **FLOATING
C190 NMASK_PRESENT/S.n0 VGND 0.01688f ; **FLOATING
C191 Q_ABSENT VGND 1.60992f
C192 NSENSE_ABSENT/G.t0 VGND 0.0339f ; **FLOATING
C193 NSENSE_ABSENT/D.n0 VGND 0.01002f ; **FLOATING
C194 NSENSE_ABSENT/D.t0 VGND 0.07034f ; **FLOATING
C195 NSENSE_ABSENT/S.t0 VGND 0.07034f ; **FLOATING
C196 NSENSE_ABSENT/S.n0 VGND 0.01688f ; **FLOATING
C197 PSENSE_ABSENT/B.n0 VGND 0.01808f ; **FLOATING
C198 PSENSE_ABSENT/B.n2 VGND 0.106f ; **FLOATING
C199 PSENSE_ABSENT/B.n3 VGND 0.01785f ; **FLOATING
C200 PSENSE_ABSENT/B.t0 VGND 0.14927f ; **FLOATING
C201 PSENSE_ABSENT/B.n5 VGND 0.01808f ; **FLOATING
C202 PSENSE_ABSENT/B.n6 VGND 0.01808f ; **FLOATING
C203 PSENSE_ABSENT/B.n7 VGND 0.106f ; **FLOATING
C204 PSENSE_ABSENT/B.n8 VGND 0.01785f ; **FLOATING
C205 PSENSE_ABSENT/G.t0 VGND 0.12235f ; **FLOATING
C206 PSENSE_ABSENT/D.n0 VGND 0.1189f ; **FLOATING
C207 PSENSE_ABSENT/D.t0 VGND 0.13145f ; **FLOATING
C208 PSENSE_ABSENT/S.t0 VGND 0.13145f ; **FLOATING
C209 Q_PRESENT VGND 1.60799f
C210 NSENSE_PRESENT/G.t0 VGND 0.0339f ; **FLOATING
C211 NSENSE_PRESENT/D.n0 VGND 0.01002f ; **FLOATING
C212 NSENSE_PRESENT/D.t0 VGND 0.07034f ; **FLOATING
C213 NSENSE_PRESENT/S.t0 VGND 0.07034f ; **FLOATING
C214 NSENSE_PRESENT/S.n0 VGND 0.01688f ; **FLOATING
C215 VPWR VGND 8.02339f
C216 PRE_PRESENT VGND 0.54863f
C217 PPRE_PRESENT/B.n0 VGND 0.01808f ; **FLOATING
C218 PPRE_PRESENT/B.n2 VGND 0.106f ; **FLOATING
C219 PPRE_PRESENT/B.n3 VGND 0.01785f ; **FLOATING
C220 PPRE_PRESENT/B.t0 VGND 0.14927f ; **FLOATING
C221 PPRE_PRESENT/B.n5 VGND 0.01808f ; **FLOATING
C222 PPRE_PRESENT/B.n6 VGND 0.01808f ; **FLOATING
C223 PPRE_PRESENT/B.n7 VGND 0.106f ; **FLOATING
C224 PPRE_PRESENT/B.n8 VGND 0.01785f ; **FLOATING
C225 PPRE_PRESENT/G.t0 VGND 0.12235f ; **FLOATING
C226 PPRE_PRESENT/D.n0 VGND 0.1189f ; **FLOATING
C227 PPRE_PRESENT/D.t0 VGND 0.13145f ; **FLOATING
C228 PPRE_PRESENT/S.t0 VGND 0.13145f ; **FLOATING
C229 NROW_PRESENT/S VGND 1.40979f
C230 BL_PRESENT VGND 3.67491f
C231 WL_PRESENT VGND 0.79973f
C232 NROW_PRESENT/G.t0 VGND 0.0339f ; **FLOATING
C233 NROW_PRESENT/D.n0 VGND 0.01002f ; **FLOATING
C234 NROW_PRESENT/D.t0 VGND 0.07034f ; **FLOATING
C235 NROW_PRESENT/S.t0 VGND 0.07034f ; **FLOATING
C236 NROW_PRESENT/S.n0 VGND 0.01688f ; **FLOATING
C237 PSENSE_PRESENT/B.n0 VGND 0.01808f ; **FLOATING
C238 PSENSE_PRESENT/B.n2 VGND 0.106f ; **FLOATING
C239 PSENSE_PRESENT/B.n3 VGND 0.01785f ; **FLOATING
C240 PSENSE_PRESENT/B.t0 VGND 0.14927f ; **FLOATING
C241 PSENSE_PRESENT/B.n5 VGND 0.01808f ; **FLOATING
C242 PSENSE_PRESENT/B.n6 VGND 0.01808f ; **FLOATING
C243 PSENSE_PRESENT/B.n7 VGND 0.106f ; **FLOATING
C244 PSENSE_PRESENT/B.n8 VGND 0.01785f ; **FLOATING
C245 PSENSE_PRESENT/G.t0 VGND 0.12235f ; **FLOATING
C246 PSENSE_PRESENT/D.n0 VGND 0.1189f ; **FLOATING
C247 PSENSE_PRESENT/D.t0 VGND 0.13145f ; **FLOATING
C248 PSENSE_PRESENT/S.t0 VGND 0.13145f ; **FLOATING
C249 BL_ABSENT VGND 3.53295f
C250 PRE_ABSENT VGND 0.54818f
C251 PPRE_ABSENT/B.n0 VGND 0.01808f ; **FLOATING
C252 PPRE_ABSENT/B.n2 VGND 0.106f ; **FLOATING
C253 PPRE_ABSENT/B.n3 VGND 0.01785f ; **FLOATING
C254 PPRE_ABSENT/B.t0 VGND 0.14927f ; **FLOATING
C255 PPRE_ABSENT/B.n5 VGND 0.01808f ; **FLOATING
C256 PPRE_ABSENT/B.n6 VGND 0.01808f ; **FLOATING
C257 PPRE_ABSENT/B.n7 VGND 0.106f ; **FLOATING
C258 PPRE_ABSENT/B.n8 VGND 0.01785f ; **FLOATING
C259 PPRE_ABSENT/G.t0 VGND 0.12235f ; **FLOATING
C260 PPRE_ABSENT/D.n0 VGND 0.1189f ; **FLOATING
C261 PPRE_ABSENT/D.t0 VGND 0.13145f ; **FLOATING
C262 PPRE_ABSENT/S.t0 VGND 0.13145f ; **FLOATING
C263 EN_ABSENT VGND 0.82465f
C264 NMASK_ABSENT/G.t0 VGND 0.0339f ; **FLOATING
C265 NMASK_ABSENT/D.n0 VGND 0.01002f ; **FLOATING
C266 NMASK_ABSENT/D.t0 VGND 0.07034f ; **FLOATING
C267 NMASK_ABSENT/S.t0 VGND 0.07034f ; **FLOATING
C268 NMASK_ABSENT/S.n0 VGND 0.01688f ; **FLOATING
.ends
