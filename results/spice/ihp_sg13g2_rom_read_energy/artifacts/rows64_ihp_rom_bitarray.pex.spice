* NGSPICE file created from ihp_rom_bitarray.ext - technology: ihp-sg13g2

.subckt ihp_rom_bitarray VSS WL0 WL1 WL2 WL3 WL4 WL5 WL6 WL7 WL8 WL9 WL10 WL11 WL12
+ WL13 WL14 WL15 WL16 WL17 WL18 WL19 WL20 WL21 WL22 WL23 WL24 WL25 WL26 WL27 WL28
+ WL29 WL30 WL31 WL32 WL33 WL34 WL35 WL36 WL37 WL38 WL39 WL40 WL41 WL42 WL43 WL44
+ WL45 WL46 WL47 WL48 WL49 WL50 WL51 WL52 WL53 WL54 WL55 WL56 WL57 WL58 WL59 WL60
+ WL61 WL62 WL63 BL0 BL1 BL2 BL3 BL4 BL5 BL6 BL7
X0 VSS WL13 a_327_2010# VSS sg13_lv_nmos ad=57f pd=0.68u as=0.102p ps=1.28u w=0.3u l=0.13u
X1 a_21_8020# WL52 VSS VSS sg13_lv_nmos ad=0.102p pd=1.28u as=57f ps=0.68u w=0.3u l=0.13u
X2 BL3 WL38 VSS VSS sg13_lv_nmos ad=0.102p pd=1.28u as=57f ps=0.68u w=0.3u l=0.13u
X3 VSS WL61 a_633_9354# VSS sg13_lv_nmos ad=57f pd=0.68u as=0.102p ps=1.28u w=0.3u l=0.13u
X4 BL1 WL28 VSS VSS sg13_lv_nmos ad=0.102p pd=1.28u as=57f ps=0.68u w=0.3u l=0.13u
X5 VSS WL23 a_531_3540# VSS sg13_lv_nmos ad=57f pd=0.68u as=0.102p ps=1.28u w=0.3u l=0.13u
X6 VSS WL61 a_327_9354# VSS sg13_lv_nmos ad=57f pd=0.68u as=0.102p ps=1.28u w=0.3u l=0.13u
X7 VSS WL5 a_225_786# VSS sg13_lv_nmos ad=57f pd=0.68u as=0.102p ps=1.28u w=0.3u l=0.13u
X8 VSS WL23 a_225_3540# VSS sg13_lv_nmos ad=57f pd=0.68u as=0.102p ps=1.28u w=0.3u l=0.13u
X9 BL6 WL32 VSS VSS sg13_lv_nmos ad=0.102p pd=1.28u as=57f ps=0.68u w=0.3u l=0.13u
X10 BL0 WL26 VSS VSS sg13_lv_nmos ad=0.102p pd=1.28u as=57f ps=0.68u w=0.3u l=0.13u
X11 a_735_2512# WL16 VSS VSS sg13_lv_nmos ad=0.102p pd=1.28u as=57f ps=0.68u w=0.3u l=0.13u
X12 BL3 WL32 VSS VSS sg13_lv_nmos ad=0.102p pd=1.28u as=57f ps=0.68u w=0.3u l=0.13u
X13 a_429_2512# WL16 VSS VSS sg13_lv_nmos ad=0.102p pd=1.28u as=57f ps=0.68u w=0.3u l=0.13u
X14 VSS WL55 a_633_8436# VSS sg13_lv_nmos ad=57f pd=0.68u as=0.102p ps=1.28u w=0.3u l=0.13u
X15 BL1 WL22 VSS VSS sg13_lv_nmos ad=0.102p pd=1.28u as=57f ps=0.68u w=0.3u l=0.13u
X16 VSS WL55 a_327_8436# VSS sg13_lv_nmos ad=57f pd=0.68u as=0.102p ps=1.28u w=0.3u l=0.13u
X17 VSS WL39 BL7 VSS sg13_lv_nmos ad=57f pd=0.68u as=0.102p ps=1.28u w=0.3u l=0.13u
X18 VSS WL39 BL4 VSS sg13_lv_nmos ad=57f pd=0.68u as=0.102p ps=1.28u w=0.3u l=0.13u
X19 a_735_1594# WL10 VSS VSS sg13_lv_nmos ad=0.102p pd=1.28u as=57f ps=0.68u w=0.3u l=0.13u
X20 BL5 WL54 VSS VSS sg13_lv_nmos ad=0.102p pd=1.28u as=57f ps=0.68u w=0.3u l=0.13u
X21 VSS WL49 BL5 VSS sg13_lv_nmos ad=57f pd=0.68u as=0.102p ps=1.28u w=0.3u l=0.13u
X22 a_429_1594# WL10 VSS VSS sg13_lv_nmos ad=0.102p pd=1.28u as=57f ps=0.68u w=0.3u l=0.13u
X23 BL2 WL54 VSS VSS sg13_lv_nmos ad=0.102p pd=1.28u as=57f ps=0.68u w=0.3u l=0.13u
X24 VSS WL49 BL2 VSS sg13_lv_nmos ad=57f pd=0.68u as=0.102p ps=1.28u w=0.3u l=0.13u
X25 BL2 WL0 VSS VSS sg13_lv_nmos ad=0.102p pd=1.28u as=0.114p ps=1.36u w=0.3u l=0.13u
X26 VSS WL63 BL0 VSS sg13_lv_nmos ad=0.114p pd=1.36u as=0.102p ps=1.28u w=0.3u l=0.13u
X27 VSS WL33 BL7 VSS sg13_lv_nmos ad=57f pd=0.68u as=0.102p ps=1.28u w=0.3u l=0.13u
X28 a_735_8938# WL58 VSS VSS sg13_lv_nmos ad=0.102p pd=1.28u as=57f ps=0.68u w=0.3u l=0.13u
X29 BL6 WL2 VSS VSS sg13_lv_nmos ad=0.102p pd=1.28u as=57f ps=0.68u w=0.3u l=0.13u
X30 VSS WL27 a_21_4152# VSS sg13_lv_nmos ad=57f pd=0.68u as=0.102p ps=1.28u w=0.3u l=0.13u
X31 VSS WL33 BL4 VSS sg13_lv_nmos ad=57f pd=0.68u as=0.102p ps=1.28u w=0.3u l=0.13u
X32 a_429_8938# WL58 VSS VSS sg13_lv_nmos ad=0.102p pd=1.28u as=57f ps=0.68u w=0.3u l=0.13u
X33 VSS WL17 a_735_2622# VSS sg13_lv_nmos ad=57f pd=0.68u as=0.102p ps=1.28u w=0.3u l=0.13u
X34 BL1 WL48 VSS VSS sg13_lv_nmos ad=0.102p pd=1.28u as=57f ps=0.68u w=0.3u l=0.13u
X35 VSS WL43 BL5 VSS sg13_lv_nmos ad=57f pd=0.68u as=0.102p ps=1.28u w=0.3u l=0.13u
X36 VSS WL17 a_429_2622# VSS sg13_lv_nmos ad=57f pd=0.68u as=0.102p ps=1.28u w=0.3u l=0.13u
X37 a_633_8020# WL52 VSS VSS sg13_lv_nmos ad=0.102p pd=1.28u as=57f ps=0.68u w=0.3u l=0.13u
X38 VSS WL7 BL5 VSS sg13_lv_nmos ad=57f pd=0.68u as=0.102p ps=1.28u w=0.3u l=0.13u
X39 VSS WL43 BL2 VSS sg13_lv_nmos ad=57f pd=0.68u as=0.102p ps=1.28u w=0.3u l=0.13u
X40 a_21_7102# WL46 VSS VSS sg13_lv_nmos ad=0.102p pd=1.28u as=57f ps=0.68u w=0.3u l=0.13u
X41 VSS WL7 BL2 VSS sg13_lv_nmos ad=57f pd=0.68u as=0.102p ps=1.28u w=0.3u l=0.13u
X42 VSS WL5 BL3 VSS sg13_lv_nmos ad=57f pd=0.68u as=0.102p ps=1.28u w=0.3u l=0.13u
X43 a_327_8020# WL52 VSS VSS sg13_lv_nmos ad=0.102p pd=1.28u as=57f ps=0.68u w=0.3u l=0.13u
X44 VSS WL21 a_21_3234# VSS sg13_lv_nmos ad=57f pd=0.68u as=0.102p ps=1.28u w=0.3u l=0.13u
X45 VSS WL11 a_735_1704# VSS sg13_lv_nmos ad=57f pd=0.68u as=0.102p ps=1.28u w=0.3u l=0.13u
X46 BL1 WL42 VSS VSS sg13_lv_nmos ad=0.102p pd=1.28u as=57f ps=0.68u w=0.3u l=0.13u
X47 VSS WL11 a_429_1704# VSS sg13_lv_nmos ad=57f pd=0.68u as=0.102p ps=1.28u w=0.3u l=0.13u
X48 BL6 WL26 VSS VSS sg13_lv_nmos ad=0.102p pd=1.28u as=57f ps=0.68u w=0.3u l=0.13u
X49 a_21_6184# WL40 VSS VSS sg13_lv_nmos ad=0.102p pd=1.28u as=57f ps=0.68u w=0.3u l=0.13u
X50 BL3 WL26 VSS VSS sg13_lv_nmos ad=0.102p pd=1.28u as=57f ps=0.68u w=0.3u l=0.13u
X51 a_531_3124# WL20 VSS VSS sg13_lv_nmos ad=0.102p pd=1.28u as=57f ps=0.68u w=0.3u l=0.13u
X52 a_123_5572# WL36 VSS VSS sg13_lv_nmos ad=0.102p pd=1.28u as=57f ps=0.68u w=0.3u l=0.13u
X53 VSS WL53 a_735_8130# VSS sg13_lv_nmos ad=57f pd=0.68u as=0.102p ps=1.28u w=0.3u l=0.13u
X54 a_225_3124# WL20 VSS VSS sg13_lv_nmos ad=0.102p pd=1.28u as=57f ps=0.68u w=0.3u l=0.13u
X55 VSS WL53 a_429_8130# VSS sg13_lv_nmos ad=57f pd=0.68u as=0.102p ps=1.28u w=0.3u l=0.13u
X56 VSS WL47 a_21_7212# VSS sg13_lv_nmos ad=57f pd=0.68u as=0.102p ps=1.28u w=0.3u l=0.13u
X57 BL0 WL2 VSS VSS sg13_lv_nmos ad=0.102p pd=1.28u as=57f ps=0.68u w=0.3u l=0.13u
X58 VSS WL59 a_123_9048# VSS sg13_lv_nmos ad=57f pd=0.68u as=0.102p ps=1.28u w=0.3u l=0.13u
X59 a_735_370# WL2 VSS VSS sg13_lv_nmos ad=0.102p pd=1.28u as=57f ps=0.68u w=0.3u l=0.13u
X60 a_21_2818# WL18 VSS VSS sg13_lv_nmos ad=0.102p pd=1.28u as=57f ps=0.68u w=0.3u l=0.13u
X61 VSS WL63 BL6 VSS sg13_lv_nmos ad=0.114p pd=1.36u as=0.102p ps=1.28u w=0.3u l=0.13u
X62 a_123_4654# WL30 VSS VSS sg13_lv_nmos ad=0.102p pd=1.28u as=57f ps=0.68u w=0.3u l=0.13u
X63 VSS WL63 BL3 VSS sg13_lv_nmos ad=0.114p pd=1.36u as=0.102p ps=1.28u w=0.3u l=0.13u
X64 VSS WL27 a_633_4152# VSS sg13_lv_nmos ad=57f pd=0.68u as=0.102p ps=1.28u w=0.3u l=0.13u
X65 VSS WL27 a_327_4152# VSS sg13_lv_nmos ad=57f pd=0.68u as=0.102p ps=1.28u w=0.3u l=0.13u
X66 VSS WL41 BL0 VSS sg13_lv_nmos ad=57f pd=0.68u as=0.102p ps=1.28u w=0.3u l=0.13u
X67 VSS WL5 a_429_786# VSS sg13_lv_nmos ad=57f pd=0.68u as=0.102p ps=1.28u w=0.3u l=0.13u
X68 a_531_9550# WL62 VSS VSS sg13_lv_nmos ad=0.102p pd=1.28u as=57f ps=0.68u w=0.3u l=0.13u
X69 a_21_1900# WL12 VSS VSS sg13_lv_nmos ad=0.102p pd=1.28u as=57f ps=0.68u w=0.3u l=0.13u
X70 a_225_9550# WL62 VSS VSS sg13_lv_nmos ad=0.102p pd=1.28u as=57f ps=0.68u w=0.3u l=0.13u
X71 a_633_7102# WL46 VSS VSS sg13_lv_nmos ad=0.102p pd=1.28u as=57f ps=0.68u w=0.3u l=0.13u
X72 VSS WL37 a_123_5682# VSS sg13_lv_nmos ad=57f pd=0.68u as=0.102p ps=1.28u w=0.3u l=0.13u
X73 a_327_7102# WL46 VSS VSS sg13_lv_nmos ad=0.102p pd=1.28u as=57f ps=0.68u w=0.3u l=0.13u
X74 VSS WL21 a_633_3234# VSS sg13_lv_nmos ad=57f pd=0.68u as=0.102p ps=1.28u w=0.3u l=0.13u
X75 VSS WL5 a_531_786# VSS sg13_lv_nmos ad=57f pd=0.68u as=0.102p ps=1.28u w=0.3u l=0.13u
X76 VSS WL35 BL0 VSS sg13_lv_nmos ad=57f pd=0.68u as=0.102p ps=1.28u w=0.3u l=0.13u
X77 VSS WL21 a_327_3234# VSS sg13_lv_nmos ad=57f pd=0.68u as=0.102p ps=1.28u w=0.3u l=0.13u
X78 a_531_8632# WL56 VSS VSS sg13_lv_nmos ad=0.102p pd=1.28u as=57f ps=0.68u w=0.3u l=0.13u
X79 a_225_8632# WL56 VSS VSS sg13_lv_nmos ad=0.102p pd=1.28u as=57f ps=0.68u w=0.3u l=0.13u
X80 a_633_6184# WL40 VSS VSS sg13_lv_nmos ad=0.102p pd=1.28u as=57f ps=0.68u w=0.3u l=0.13u
X81 VSS WL15 a_531_2316# VSS sg13_lv_nmos ad=57f pd=0.68u as=0.102p ps=1.28u w=0.3u l=0.13u
X82 VSS WL31 BL1 VSS sg13_lv_nmos ad=57f pd=0.68u as=0.102p ps=1.28u w=0.3u l=0.13u
X83 a_327_6184# WL40 VSS VSS sg13_lv_nmos ad=0.102p pd=1.28u as=57f ps=0.68u w=0.3u l=0.13u
X84 VSS WL15 a_225_2316# VSS sg13_lv_nmos ad=57f pd=0.68u as=0.102p ps=1.28u w=0.3u l=0.13u
X85 a_735_3736# WL24 VSS VSS sg13_lv_nmos ad=0.102p pd=1.28u as=57f ps=0.68u w=0.3u l=0.13u
X86 VSS WL29 BL0 VSS sg13_lv_nmos ad=57f pd=0.68u as=0.102p ps=1.28u w=0.3u l=0.13u
X87 VSS WL19 BL7 VSS sg13_lv_nmos ad=57f pd=0.68u as=0.102p ps=1.28u w=0.3u l=0.13u
X88 a_123_7714# WL50 VSS VSS sg13_lv_nmos ad=0.102p pd=1.28u as=57f ps=0.68u w=0.3u l=0.13u
X89 a_429_3736# WL24 VSS VSS sg13_lv_nmos ad=0.102p pd=1.28u as=57f ps=0.68u w=0.3u l=0.13u
X90 VSS WL19 BL4 VSS sg13_lv_nmos ad=57f pd=0.68u as=0.102p ps=1.28u w=0.3u l=0.13u
X91 a_123_2206# WL14 VSS VSS sg13_lv_nmos ad=0.102p pd=1.28u as=57f ps=0.68u w=0.3u l=0.13u
X92 VSS WL47 a_633_7212# VSS sg13_lv_nmos ad=57f pd=0.68u as=0.102p ps=1.28u w=0.3u l=0.13u
X93 VSS WL9 a_531_1398# VSS sg13_lv_nmos ad=57f pd=0.68u as=0.102p ps=1.28u w=0.3u l=0.13u
X94 VSS WL25 BL1 VSS sg13_lv_nmos ad=57f pd=0.68u as=0.102p ps=1.28u w=0.3u l=0.13u
X95 VSS WL47 a_327_7212# VSS sg13_lv_nmos ad=57f pd=0.68u as=0.102p ps=1.28u w=0.3u l=0.13u
X96 VSS WL9 a_225_1398# VSS sg13_lv_nmos ad=57f pd=0.68u as=0.102p ps=1.28u w=0.3u l=0.13u
X97 a_633_2818# WL18 VSS VSS sg13_lv_nmos ad=0.102p pd=1.28u as=57f ps=0.68u w=0.3u l=0.13u
X98 a_327_2818# WL18 VSS VSS sg13_lv_nmos ad=0.102p pd=1.28u as=57f ps=0.68u w=0.3u l=0.13u
X99 VSS WL23 BL0 VSS sg13_lv_nmos ad=57f pd=0.68u as=0.102p ps=1.28u w=0.3u l=0.13u
X100 VSS WL57 a_531_8742# VSS sg13_lv_nmos ad=57f pd=0.68u as=0.102p ps=1.28u w=0.3u l=0.13u
X101 VSS WL57 a_225_8742# VSS sg13_lv_nmos ad=57f pd=0.68u as=0.102p ps=1.28u w=0.3u l=0.13u
X102 a_123_1288# WL8 VSS VSS sg13_lv_nmos ad=0.102p pd=1.28u as=57f ps=0.68u w=0.3u l=0.13u
X103 VSS WL41 BL6 VSS sg13_lv_nmos ad=57f pd=0.68u as=0.102p ps=1.28u w=0.3u l=0.13u
X104 VSS WL41 BL3 VSS sg13_lv_nmos ad=57f pd=0.68u as=0.102p ps=1.28u w=0.3u l=0.13u
X105 VSS WL5 BL6 VSS sg13_lv_nmos ad=57f pd=0.68u as=0.102p ps=1.28u w=0.3u l=0.13u
X106 a_633_1900# WL12 VSS VSS sg13_lv_nmos ad=0.102p pd=1.28u as=57f ps=0.68u w=0.3u l=0.13u
X107 a_327_1900# WL12 VSS VSS sg13_lv_nmos ad=0.102p pd=1.28u as=57f ps=0.68u w=0.3u l=0.13u
X108 VSS WL51 a_123_7824# VSS sg13_lv_nmos ad=57f pd=0.68u as=0.102p ps=1.28u w=0.3u l=0.13u
X109 BL7 WL60 VSS VSS sg13_lv_nmos ad=0.102p pd=1.28u as=57f ps=0.68u w=0.3u l=0.13u
X110 BL1 WL4 VSS VSS sg13_lv_nmos ad=0.102p pd=1.28u as=57f ps=0.68u w=0.3u l=0.13u
X111 VSS WL35 BL6 VSS sg13_lv_nmos ad=57f pd=0.68u as=0.102p ps=1.28u w=0.3u l=0.13u
X112 BL4 WL60 VSS VSS sg13_lv_nmos ad=0.102p pd=1.28u as=57f ps=0.68u w=0.3u l=0.13u
X113 a_21_8326# WL54 VSS VSS sg13_lv_nmos ad=0.102p pd=1.28u as=57f ps=0.68u w=0.3u l=0.13u
X114 VSS WL49 a_21_7518# VSS sg13_lv_nmos ad=57f pd=0.68u as=0.102p ps=1.28u w=0.3u l=0.13u
X115 VSS WL35 BL3 VSS sg13_lv_nmos ad=57f pd=0.68u as=0.102p ps=1.28u w=0.3u l=0.13u
X116 a_735_6796# WL44 VSS VSS sg13_lv_nmos ad=0.102p pd=1.28u as=57f ps=0.68u w=0.3u l=0.13u
X117 a_429_6796# WL44 VSS VSS sg13_lv_nmos ad=0.102p pd=1.28u as=57f ps=0.68u w=0.3u l=0.13u
X118 BL5 WL34 VSS VSS sg13_lv_nmos ad=0.102p pd=1.28u as=57f ps=0.68u w=0.3u l=0.13u
X119 VSS WL45 a_123_6906# VSS sg13_lv_nmos ad=57f pd=0.68u as=0.102p ps=1.28u w=0.3u l=0.13u
X120 BL2 WL34 VSS VSS sg13_lv_nmos ad=0.102p pd=1.28u as=57f ps=0.68u w=0.3u l=0.13u
X121 VSS WL29 BL6 VSS sg13_lv_nmos ad=57f pd=0.68u as=0.102p ps=1.28u w=0.3u l=0.13u
X122 VSS WL13 BL7 VSS sg13_lv_nmos ad=57f pd=0.68u as=0.102p ps=1.28u w=0.3u l=0.13u
X123 VSS WL43 a_21_6600# VSS sg13_lv_nmos ad=57f pd=0.68u as=0.102p ps=1.28u w=0.3u l=0.13u
X124 VSS WL29 BL3 VSS sg13_lv_nmos ad=57f pd=0.68u as=0.102p ps=1.28u w=0.3u l=0.13u
X125 a_735_5878# WL38 VSS VSS sg13_lv_nmos ad=0.102p pd=1.28u as=57f ps=0.68u w=0.3u l=0.13u
X126 VSS WL7 a_21_1092# VSS sg13_lv_nmos ad=57f pd=0.68u as=0.102p ps=1.28u w=0.3u l=0.13u
X127 VSS WL13 BL4 VSS sg13_lv_nmos ad=57f pd=0.68u as=0.102p ps=1.28u w=0.3u l=0.13u
X128 a_429_5878# WL38 VSS VSS sg13_lv_nmos ad=0.102p pd=1.28u as=57f ps=0.68u w=0.3u l=0.13u
X129 BL5 WL28 VSS VSS sg13_lv_nmos ad=0.102p pd=1.28u as=57f ps=0.68u w=0.3u l=0.13u
X130 VSS WL61 BL7 VSS sg13_lv_nmos ad=57f pd=0.68u as=0.102p ps=1.28u w=0.3u l=0.13u
X131 VSS WL23 BL6 VSS sg13_lv_nmos ad=57f pd=0.68u as=0.102p ps=1.28u w=0.3u l=0.13u
X132 BL2 WL28 VSS VSS sg13_lv_nmos ad=0.102p pd=1.28u as=57f ps=0.68u w=0.3u l=0.13u
X133 VSS WL61 BL4 VSS sg13_lv_nmos ad=57f pd=0.68u as=0.102p ps=1.28u w=0.3u l=0.13u
X134 VSS WL5 BL0 VSS sg13_lv_nmos ad=57f pd=0.68u as=0.102p ps=1.28u w=0.3u l=0.13u
X135 VSS WL23 BL3 VSS sg13_lv_nmos ad=57f pd=0.68u as=0.102p ps=1.28u w=0.3u l=0.13u
X136 a_735_4960# WL32 VSS VSS sg13_lv_nmos ad=0.102p pd=1.28u as=57f ps=0.68u w=0.3u l=0.13u
X137 VSS WL5 a_735_786# VSS sg13_lv_nmos ad=57f pd=0.68u as=0.102p ps=1.28u w=0.3u l=0.13u
X138 a_429_4960# WL32 VSS VSS sg13_lv_nmos ad=0.102p pd=1.28u as=57f ps=0.68u w=0.3u l=0.13u
X139 BL5 WL22 VSS VSS sg13_lv_nmos ad=0.102p pd=1.28u as=57f ps=0.68u w=0.3u l=0.13u
X140 VSS WL55 BL7 VSS sg13_lv_nmos ad=57f pd=0.68u as=0.102p ps=1.28u w=0.3u l=0.13u
X141 BL2 WL4 VSS VSS sg13_lv_nmos ad=0.102p pd=1.28u as=57f ps=0.68u w=0.3u l=0.13u
X142 a_633_64# WL0 VSS VSS sg13_lv_nmos ad=0.102p pd=1.28u as=0.114p ps=1.36u w=0.3u l=0.13u
X143 BL2 WL22 VSS VSS sg13_lv_nmos ad=0.102p pd=1.28u as=57f ps=0.68u w=0.3u l=0.13u
X144 VSS WL55 BL4 VSS sg13_lv_nmos ad=57f pd=0.68u as=0.102p ps=1.28u w=0.3u l=0.13u
X145 BL0 WL20 VSS VSS sg13_lv_nmos ad=0.102p pd=1.28u as=57f ps=0.68u w=0.3u l=0.13u
X146 a_633_8326# WL54 VSS VSS sg13_lv_nmos ad=0.102p pd=1.28u as=57f ps=0.68u w=0.3u l=0.13u
X147 VSS WL49 a_633_7518# VSS sg13_lv_nmos ad=57f pd=0.68u as=0.102p ps=1.28u w=0.3u l=0.13u
X148 a_123_2512# WL16 VSS VSS sg13_lv_nmos ad=0.102p pd=1.28u as=57f ps=0.68u w=0.3u l=0.13u
X149 a_327_8326# WL54 VSS VSS sg13_lv_nmos ad=0.102p pd=1.28u as=57f ps=0.68u w=0.3u l=0.13u
X150 VSS WL49 a_327_7518# VSS sg13_lv_nmos ad=57f pd=0.68u as=0.102p ps=1.28u w=0.3u l=0.13u
X151 BL5 WL48 VSS VSS sg13_lv_nmos ad=0.102p pd=1.28u as=57f ps=0.68u w=0.3u l=0.13u
X152 VSS WL39 BL1 VSS sg13_lv_nmos ad=57f pd=0.68u as=0.102p ps=1.28u w=0.3u l=0.13u
X153 BL2 WL48 VSS VSS sg13_lv_nmos ad=0.102p pd=1.28u as=57f ps=0.68u w=0.3u l=0.13u
X154 a_123_1594# WL10 VSS VSS sg13_lv_nmos ad=0.102p pd=1.28u as=57f ps=0.68u w=0.3u l=0.13u
X155 VSS WL43 a_633_6600# VSS sg13_lv_nmos ad=57f pd=0.68u as=0.102p ps=1.28u w=0.3u l=0.13u
X156 BL0 WL62 VSS VSS sg13_lv_nmos ad=0.102p pd=1.28u as=57f ps=0.68u w=0.3u l=0.13u
X157 VSS WL7 a_633_1092# VSS sg13_lv_nmos ad=57f pd=0.68u as=0.102p ps=1.28u w=0.3u l=0.13u
X158 VSS WL43 a_327_6600# VSS sg13_lv_nmos ad=57f pd=0.68u as=0.102p ps=1.28u w=0.3u l=0.13u
X159 BL7 WL52 VSS VSS sg13_lv_nmos ad=0.102p pd=1.28u as=57f ps=0.68u w=0.3u l=0.13u
X160 BL4 WL52 VSS VSS sg13_lv_nmos ad=0.102p pd=1.28u as=57f ps=0.68u w=0.3u l=0.13u
X161 VSS WL7 a_327_1092# VSS sg13_lv_nmos ad=57f pd=0.68u as=0.102p ps=1.28u w=0.3u l=0.13u
X162 a_123_8938# WL58 VSS VSS sg13_lv_nmos ad=0.102p pd=1.28u as=57f ps=0.68u w=0.3u l=0.13u
X163 VSS WL33 BL1 VSS sg13_lv_nmos ad=57f pd=0.68u as=0.102p ps=1.28u w=0.3u l=0.13u
X164 BL5 WL42 VSS VSS sg13_lv_nmos ad=0.102p pd=1.28u as=57f ps=0.68u w=0.3u l=0.13u
X165 BL2 WL42 VSS VSS sg13_lv_nmos ad=0.102p pd=1.28u as=57f ps=0.68u w=0.3u l=0.13u
X166 BL1 WL6 VSS VSS sg13_lv_nmos ad=0.102p pd=1.28u as=57f ps=0.68u w=0.3u l=0.13u
X167 VSS WL17 a_123_2622# VSS sg13_lv_nmos ad=57f pd=0.68u as=0.102p ps=1.28u w=0.3u l=0.13u
X168 BL0 WL56 VSS VSS sg13_lv_nmos ad=0.102p pd=1.28u as=57f ps=0.68u w=0.3u l=0.13u
X169 a_327_676# WL4 VSS VSS sg13_lv_nmos ad=0.102p pd=1.28u as=57f ps=0.68u w=0.3u l=0.13u
X170 a_735_4042# WL26 VSS VSS sg13_lv_nmos ad=0.102p pd=1.28u as=57f ps=0.68u w=0.3u l=0.13u
X171 a_429_4042# WL26 VSS VSS sg13_lv_nmos ad=0.102p pd=1.28u as=57f ps=0.68u w=0.3u l=0.13u
X172 VSS WL15 BL0 VSS sg13_lv_nmos ad=57f pd=0.68u as=0.102p ps=1.28u w=0.3u l=0.13u
X173 a_531_5572# WL36 VSS VSS sg13_lv_nmos ad=0.102p pd=1.28u as=57f ps=0.68u w=0.3u l=0.13u
X174 BL6 WL20 VSS VSS sg13_lv_nmos ad=0.102p pd=1.28u as=57f ps=0.68u w=0.3u l=0.13u
X175 VSS WL11 a_123_1704# VSS sg13_lv_nmos ad=57f pd=0.68u as=0.102p ps=1.28u w=0.3u l=0.13u
X176 a_225_5572# WL36 VSS VSS sg13_lv_nmos ad=0.102p pd=1.28u as=57f ps=0.68u w=0.3u l=0.13u
X177 BL3 WL20 VSS VSS sg13_lv_nmos ad=0.102p pd=1.28u as=57f ps=0.68u w=0.3u l=0.13u
X178 VSS WL59 a_531_9048# VSS sg13_lv_nmos ad=57f pd=0.68u as=0.102p ps=1.28u w=0.3u l=0.13u
X179 VSS WL9 BL0 VSS sg13_lv_nmos ad=57f pd=0.68u as=0.102p ps=1.28u w=0.3u l=0.13u
X180 VSS WL59 a_225_9048# VSS sg13_lv_nmos ad=57f pd=0.68u as=0.102p ps=1.28u w=0.3u l=0.13u
X181 a_531_4654# WL30 VSS VSS sg13_lv_nmos ad=0.102p pd=1.28u as=57f ps=0.68u w=0.3u l=0.13u
X182 VSS WL63 a_735_9660# VSS sg13_lv_nmos ad=0.114p pd=1.36u as=0.102p ps=1.28u w=0.3u l=0.13u
X183 a_225_4654# WL30 VSS VSS sg13_lv_nmos ad=0.102p pd=1.28u as=57f ps=0.68u w=0.3u l=0.13u
X184 VSS WL63 a_429_9660# VSS sg13_lv_nmos ad=0.114p pd=1.36u as=0.102p ps=1.28u w=0.3u l=0.13u
X185 VSS WL57 BL0 VSS sg13_lv_nmos ad=57f pd=0.68u as=0.102p ps=1.28u w=0.3u l=0.13u
X186 VSS WL27 BL7 VSS sg13_lv_nmos ad=57f pd=0.68u as=0.102p ps=1.28u w=0.3u l=0.13u
X187 VSS WL53 a_123_8130# VSS sg13_lv_nmos ad=57f pd=0.68u as=0.102p ps=1.28u w=0.3u l=0.13u
X188 BL1 WL0 VSS VSS sg13_lv_nmos ad=0.102p pd=1.28u as=0.114p ps=1.36u w=0.3u l=0.13u
X189 VSS WL27 BL4 VSS sg13_lv_nmos ad=57f pd=0.68u as=0.102p ps=1.28u w=0.3u l=0.13u
X190 BL6 WL62 VSS VSS sg13_lv_nmos ad=0.102p pd=1.28u as=57f ps=0.68u w=0.3u l=0.13u
X191 VSS WL37 a_531_5682# VSS sg13_lv_nmos ad=57f pd=0.68u as=0.102p ps=1.28u w=0.3u l=0.13u
X192 BL7 WL46 VSS VSS sg13_lv_nmos ad=0.102p pd=1.28u as=57f ps=0.68u w=0.3u l=0.13u
X193 BL3 WL62 VSS VSS sg13_lv_nmos ad=0.102p pd=1.28u as=57f ps=0.68u w=0.3u l=0.13u
X194 BL2 WL6 VSS VSS sg13_lv_nmos ad=0.102p pd=1.28u as=57f ps=0.68u w=0.3u l=0.13u
X195 VSS WL37 a_225_5682# VSS sg13_lv_nmos ad=57f pd=0.68u as=0.102p ps=1.28u w=0.3u l=0.13u
X196 BL4 WL4 VSS VSS sg13_lv_nmos ad=0.102p pd=1.28u as=57f ps=0.68u w=0.3u l=0.13u
X197 BL4 WL46 VSS VSS sg13_lv_nmos ad=0.102p pd=1.28u as=57f ps=0.68u w=0.3u l=0.13u
X198 VSS WL21 BL7 VSS sg13_lv_nmos ad=57f pd=0.68u as=0.102p ps=1.28u w=0.3u l=0.13u
X199 BL4 WL0 VSS VSS sg13_lv_nmos ad=0.102p pd=1.28u as=0.114p ps=1.36u w=0.3u l=0.13u
X200 VSS WL21 BL4 VSS sg13_lv_nmos ad=57f pd=0.68u as=0.102p ps=1.28u w=0.3u l=0.13u
X201 BL6 WL56 VSS VSS sg13_lv_nmos ad=0.102p pd=1.28u as=57f ps=0.68u w=0.3u l=0.13u
X202 VSS WL31 BL5 VSS sg13_lv_nmos ad=57f pd=0.68u as=0.102p ps=1.28u w=0.3u l=0.13u
X203 BL3 WL56 VSS VSS sg13_lv_nmos ad=0.102p pd=1.28u as=57f ps=0.68u w=0.3u l=0.13u
X204 VSS WL15 BL6 VSS sg13_lv_nmos ad=57f pd=0.68u as=0.102p ps=1.28u w=0.3u l=0.13u
X205 BL7 WL40 VSS VSS sg13_lv_nmos ad=0.102p pd=1.28u as=57f ps=0.68u w=0.3u l=0.13u
X206 BL5 WL4 VSS VSS sg13_lv_nmos ad=0.102p pd=1.28u as=57f ps=0.68u w=0.3u l=0.13u
X207 VSS WL31 BL2 VSS sg13_lv_nmos ad=57f pd=0.68u as=0.102p ps=1.28u w=0.3u l=0.13u
X208 a_21_5266# WL34 VSS VSS sg13_lv_nmos ad=0.102p pd=1.28u as=57f ps=0.68u w=0.3u l=0.13u
X209 BL4 WL40 VSS VSS sg13_lv_nmos ad=0.102p pd=1.28u as=57f ps=0.68u w=0.3u l=0.13u
X210 VSS WL15 BL3 VSS sg13_lv_nmos ad=57f pd=0.68u as=0.102p ps=1.28u w=0.3u l=0.13u
X211 a_531_7714# WL50 VSS VSS sg13_lv_nmos ad=0.102p pd=1.28u as=57f ps=0.68u w=0.3u l=0.13u
X212 a_225_7714# WL50 VSS VSS sg13_lv_nmos ad=0.102p pd=1.28u as=57f ps=0.68u w=0.3u l=0.13u
X213 a_531_2206# WL14 VSS VSS sg13_lv_nmos ad=0.102p pd=1.28u as=57f ps=0.68u w=0.3u l=0.13u
X214 VSS WL25 BL5 VSS sg13_lv_nmos ad=57f pd=0.68u as=0.102p ps=1.28u w=0.3u l=0.13u
X215 VSS WL47 BL7 VSS sg13_lv_nmos ad=57f pd=0.68u as=0.102p ps=1.28u w=0.3u l=0.13u
X216 VSS WL9 BL6 VSS sg13_lv_nmos ad=57f pd=0.68u as=0.102p ps=1.28u w=0.3u l=0.13u
X217 a_225_2206# WL14 VSS VSS sg13_lv_nmos ad=0.102p pd=1.28u as=57f ps=0.68u w=0.3u l=0.13u
X218 VSS WL25 BL2 VSS sg13_lv_nmos ad=57f pd=0.68u as=0.102p ps=1.28u w=0.3u l=0.13u
X219 a_21_4348# WL28 VSS VSS sg13_lv_nmos ad=0.102p pd=1.28u as=57f ps=0.68u w=0.3u l=0.13u
X220 VSS WL47 BL4 VSS sg13_lv_nmos ad=57f pd=0.68u as=0.102p ps=1.28u w=0.3u l=0.13u
X221 VSS WL9 BL3 VSS sg13_lv_nmos ad=57f pd=0.68u as=0.102p ps=1.28u w=0.3u l=0.13u
X222 BL7 WL18 VSS VSS sg13_lv_nmos ad=0.102p pd=1.28u as=57f ps=0.68u w=0.3u l=0.13u
X223 VSS WL1 BL1 VSS sg13_lv_nmos ad=57f pd=0.68u as=0.102p ps=1.28u w=0.3u l=0.13u
X224 BL4 WL18 VSS VSS sg13_lv_nmos ad=0.102p pd=1.28u as=57f ps=0.68u w=0.3u l=0.13u
X225 VSS WL57 BL6 VSS sg13_lv_nmos ad=57f pd=0.68u as=0.102p ps=1.28u w=0.3u l=0.13u
X226 a_531_1288# WL8 VSS VSS sg13_lv_nmos ad=0.102p pd=1.28u as=57f ps=0.68u w=0.3u l=0.13u
X227 VSS WL19 BL1 VSS sg13_lv_nmos ad=57f pd=0.68u as=0.102p ps=1.28u w=0.3u l=0.13u
X228 a_123_3736# WL24 VSS VSS sg13_lv_nmos ad=0.102p pd=1.28u as=57f ps=0.68u w=0.3u l=0.13u
X229 VSS WL41 a_735_6294# VSS sg13_lv_nmos ad=57f pd=0.68u as=0.102p ps=1.28u w=0.3u l=0.13u
X230 VSS WL57 BL3 VSS sg13_lv_nmos ad=57f pd=0.68u as=0.102p ps=1.28u w=0.3u l=0.13u
X231 a_225_1288# WL8 VSS VSS sg13_lv_nmos ad=0.102p pd=1.28u as=57f ps=0.68u w=0.3u l=0.13u
X232 a_327_982# WL6 VSS VSS sg13_lv_nmos ad=0.102p pd=1.28u as=57f ps=0.68u w=0.3u l=0.13u
X233 a_21_3430# WL22 VSS VSS sg13_lv_nmos ad=0.102p pd=1.28u as=57f ps=0.68u w=0.3u l=0.13u
X234 VSS WL41 a_429_6294# VSS sg13_lv_nmos ad=57f pd=0.68u as=0.102p ps=1.28u w=0.3u l=0.13u
X235 BL7 WL12 VSS VSS sg13_lv_nmos ad=0.102p pd=1.28u as=57f ps=0.68u w=0.3u l=0.13u
X236 VSS WL51 a_531_7824# VSS sg13_lv_nmos ad=57f pd=0.68u as=0.102p ps=1.28u w=0.3u l=0.13u
X237 BL4 WL12 VSS VSS sg13_lv_nmos ad=0.102p pd=1.28u as=57f ps=0.68u w=0.3u l=0.13u
X238 VSS WL51 a_225_7824# VSS sg13_lv_nmos ad=57f pd=0.68u as=0.102p ps=1.28u w=0.3u l=0.13u
X239 VSS WL35 a_735_5376# VSS sg13_lv_nmos ad=57f pd=0.68u as=0.102p ps=1.28u w=0.3u l=0.13u
X240 a_633_676# WL4 VSS VSS sg13_lv_nmos ad=0.102p pd=1.28u as=57f ps=0.68u w=0.3u l=0.13u
X241 VSS WL35 a_429_5376# VSS sg13_lv_nmos ad=57f pd=0.68u as=0.102p ps=1.28u w=0.3u l=0.13u
X242 VSS WL45 a_531_6906# VSS sg13_lv_nmos ad=57f pd=0.68u as=0.102p ps=1.28u w=0.3u l=0.13u
X243 a_633_5266# WL34 VSS VSS sg13_lv_nmos ad=0.102p pd=1.28u as=57f ps=0.68u w=0.3u l=0.13u
X244 VSS WL45 a_225_6906# VSS sg13_lv_nmos ad=57f pd=0.68u as=0.102p ps=1.28u w=0.3u l=0.13u
X245 a_21_7408# WL48 VSS VSS sg13_lv_nmos ad=0.102p pd=1.28u as=57f ps=0.68u w=0.3u l=0.13u
X246 a_327_5266# WL34 VSS VSS sg13_lv_nmos ad=0.102p pd=1.28u as=57f ps=0.68u w=0.3u l=0.13u
X247 VSS WL29 a_735_4458# VSS sg13_lv_nmos ad=57f pd=0.68u as=0.102p ps=1.28u w=0.3u l=0.13u
X248 BL1 WL60 VSS VSS sg13_lv_nmos ad=0.102p pd=1.28u as=57f ps=0.68u w=0.3u l=0.13u
X249 VSS WL29 a_429_4458# VSS sg13_lv_nmos ad=57f pd=0.68u as=0.102p ps=1.28u w=0.3u l=0.13u
X250 a_123_6796# WL44 VSS VSS sg13_lv_nmos ad=0.102p pd=1.28u as=57f ps=0.68u w=0.3u l=0.13u
X251 VSS WL1 BL2 VSS sg13_lv_nmos ad=57f pd=0.68u as=0.102p ps=1.28u w=0.3u l=0.13u
X252 a_633_4348# WL28 VSS VSS sg13_lv_nmos ad=0.102p pd=1.28u as=57f ps=0.68u w=0.3u l=0.13u
X253 BL4 WL6 VSS VSS sg13_lv_nmos ad=0.102p pd=1.28u as=57f ps=0.68u w=0.3u l=0.13u
X254 a_327_4348# WL28 VSS VSS sg13_lv_nmos ad=0.102p pd=1.28u as=57f ps=0.68u w=0.3u l=0.13u
X255 a_21_6490# WL42 VSS VSS sg13_lv_nmos ad=0.102p pd=1.28u as=57f ps=0.68u w=0.3u l=0.13u
X256 VSS WL23 a_735_3540# VSS sg13_lv_nmos ad=57f pd=0.68u as=0.102p ps=1.28u w=0.3u l=0.13u
X257 VSS WL23 a_429_3540# VSS sg13_lv_nmos ad=57f pd=0.68u as=0.102p ps=1.28u w=0.3u l=0.13u
X258 VSS WL13 BL1 VSS sg13_lv_nmos ad=57f pd=0.68u as=0.102p ps=1.28u w=0.3u l=0.13u
X259 a_123_5878# WL38 VSS VSS sg13_lv_nmos ad=0.102p pd=1.28u as=57f ps=0.68u w=0.3u l=0.13u
X260 a_633_3430# WL22 VSS VSS sg13_lv_nmos ad=0.102p pd=1.28u as=57f ps=0.68u w=0.3u l=0.13u
X261 BL5 WL6 VSS VSS sg13_lv_nmos ad=0.102p pd=1.28u as=57f ps=0.68u w=0.3u l=0.13u
X262 a_21_676# WL4 VSS VSS sg13_lv_nmos ad=0.102p pd=1.28u as=57f ps=0.68u w=0.3u l=0.13u
X263 a_327_3430# WL22 VSS VSS sg13_lv_nmos ad=0.102p pd=1.28u as=57f ps=0.68u w=0.3u l=0.13u
X264 BL0 WL36 VSS VSS sg13_lv_nmos ad=0.102p pd=1.28u as=57f ps=0.68u w=0.3u l=0.13u
X265 BL7 WL4 VSS VSS sg13_lv_nmos ad=0.102p pd=1.28u as=57f ps=0.68u w=0.3u l=0.13u
X266 VSS WL61 BL1 VSS sg13_lv_nmos ad=57f pd=0.68u as=0.102p ps=1.28u w=0.3u l=0.13u
X267 a_531_2512# WL16 VSS VSS sg13_lv_nmos ad=0.102p pd=1.28u as=57f ps=0.68u w=0.3u l=0.13u
X268 VSS WL59 BL0 VSS sg13_lv_nmos ad=57f pd=0.68u as=0.102p ps=1.28u w=0.3u l=0.13u
X269 a_123_4960# WL32 VSS VSS sg13_lv_nmos ad=0.102p pd=1.28u as=57f ps=0.68u w=0.3u l=0.13u
X270 BL7 WL54 VSS VSS sg13_lv_nmos ad=0.102p pd=1.28u as=57f ps=0.68u w=0.3u l=0.13u
X271 VSS WL49 BL7 VSS sg13_lv_nmos ad=57f pd=0.68u as=0.102p ps=1.28u w=0.3u l=0.13u
X272 a_225_2512# WL16 VSS VSS sg13_lv_nmos ad=0.102p pd=1.28u as=57f ps=0.68u w=0.3u l=0.13u
X273 BL4 WL54 VSS VSS sg13_lv_nmos ad=0.102p pd=1.28u as=57f ps=0.68u w=0.3u l=0.13u
X274 VSS WL49 BL4 VSS sg13_lv_nmos ad=57f pd=0.68u as=0.102p ps=1.28u w=0.3u l=0.13u
X275 BL0 WL30 VSS VSS sg13_lv_nmos ad=0.102p pd=1.28u as=57f ps=0.68u w=0.3u l=0.13u
X276 VSS WL55 BL1 VSS sg13_lv_nmos ad=57f pd=0.68u as=0.102p ps=1.28u w=0.3u l=0.13u
X277 VSS WL39 BL5 VSS sg13_lv_nmos ad=57f pd=0.68u as=0.102p ps=1.28u w=0.3u l=0.13u
X278 a_633_7408# WL48 VSS VSS sg13_lv_nmos ad=0.102p pd=1.28u as=57f ps=0.68u w=0.3u l=0.13u
X279 VSS WL39 BL2 VSS sg13_lv_nmos ad=57f pd=0.68u as=0.102p ps=1.28u w=0.3u l=0.13u
X280 a_531_1594# WL10 VSS VSS sg13_lv_nmos ad=0.102p pd=1.28u as=57f ps=0.68u w=0.3u l=0.13u
X281 VSS WL3 a_123_480# VSS sg13_lv_nmos ad=57f pd=0.68u as=0.102p ps=1.28u w=0.3u l=0.13u
X282 VSS WL1 a_327_174# VSS sg13_lv_nmos ad=57f pd=0.68u as=0.102p ps=1.28u w=0.3u l=0.13u
X283 a_327_7408# WL48 VSS VSS sg13_lv_nmos ad=0.102p pd=1.28u as=57f ps=0.68u w=0.3u l=0.13u
X284 a_225_1594# WL10 VSS VSS sg13_lv_nmos ad=0.102p pd=1.28u as=57f ps=0.68u w=0.3u l=0.13u
X285 VSS WL43 BL7 VSS sg13_lv_nmos ad=57f pd=0.68u as=0.102p ps=1.28u w=0.3u l=0.13u
X286 VSS WL7 BL7 VSS sg13_lv_nmos ad=57f pd=0.68u as=0.102p ps=1.28u w=0.3u l=0.13u
X287 VSS WL37 BL0 VSS sg13_lv_nmos ad=57f pd=0.68u as=0.102p ps=1.28u w=0.3u l=0.13u
X288 VSS WL43 BL4 VSS sg13_lv_nmos ad=57f pd=0.68u as=0.102p ps=1.28u w=0.3u l=0.13u
X289 a_531_8938# WL58 VSS VSS sg13_lv_nmos ad=0.102p pd=1.28u as=57f ps=0.68u w=0.3u l=0.13u
X290 VSS WL7 BL4 VSS sg13_lv_nmos ad=57f pd=0.68u as=0.102p ps=1.28u w=0.3u l=0.13u
X291 VSS WL33 BL5 VSS sg13_lv_nmos ad=57f pd=0.68u as=0.102p ps=1.28u w=0.3u l=0.13u
X292 VSS WL33 BL2 VSS sg13_lv_nmos ad=57f pd=0.68u as=0.102p ps=1.28u w=0.3u l=0.13u
X293 a_225_8938# WL58 VSS VSS sg13_lv_nmos ad=0.102p pd=1.28u as=57f ps=0.68u w=0.3u l=0.13u
X294 VSS WL17 a_531_2622# VSS sg13_lv_nmos ad=57f pd=0.68u as=0.102p ps=1.28u w=0.3u l=0.13u
X295 a_633_6490# WL42 VSS VSS sg13_lv_nmos ad=0.102p pd=1.28u as=57f ps=0.68u w=0.3u l=0.13u
X296 a_327_6490# WL42 VSS VSS sg13_lv_nmos ad=0.102p pd=1.28u as=57f ps=0.68u w=0.3u l=0.13u
X297 VSS WL17 a_225_2622# VSS sg13_lv_nmos ad=57f pd=0.68u as=0.102p ps=1.28u w=0.3u l=0.13u
X298 a_633_982# WL6 VSS VSS sg13_lv_nmos ad=0.102p pd=1.28u as=57f ps=0.68u w=0.3u l=0.13u
X299 VSS WL31 a_21_4764# VSS sg13_lv_nmos ad=57f pd=0.68u as=0.102p ps=1.28u w=0.3u l=0.13u
X300 BL1 WL52 VSS VSS sg13_lv_nmos ad=0.102p pd=1.28u as=57f ps=0.68u w=0.3u l=0.13u
X301 VSS WL11 a_531_1704# VSS sg13_lv_nmos ad=57f pd=0.68u as=0.102p ps=1.28u w=0.3u l=0.13u
X302 BL6 WL36 VSS VSS sg13_lv_nmos ad=0.102p pd=1.28u as=57f ps=0.68u w=0.3u l=0.13u
X303 BL0 WL50 VSS VSS sg13_lv_nmos ad=0.102p pd=1.28u as=57f ps=0.68u w=0.3u l=0.13u
X304 a_735_3124# WL20 VSS VSS sg13_lv_nmos ad=0.102p pd=1.28u as=57f ps=0.68u w=0.3u l=0.13u
X305 BL3 WL36 VSS VSS sg13_lv_nmos ad=0.102p pd=1.28u as=57f ps=0.68u w=0.3u l=0.13u
X306 VSS WL11 a_225_1704# VSS sg13_lv_nmos ad=57f pd=0.68u as=0.102p ps=1.28u w=0.3u l=0.13u
X307 BL0 WL14 VSS VSS sg13_lv_nmos ad=0.102p pd=1.28u as=57f ps=0.68u w=0.3u l=0.13u
X308 a_429_3124# WL20 VSS VSS sg13_lv_nmos ad=0.102p pd=1.28u as=57f ps=0.68u w=0.3u l=0.13u
X309 VSS WL25 a_21_3846# VSS sg13_lv_nmos ad=57f pd=0.68u as=0.102p ps=1.28u w=0.3u l=0.13u
X310 VSS WL59 BL6 VSS sg13_lv_nmos ad=57f pd=0.68u as=0.102p ps=1.28u w=0.3u l=0.13u
X311 a_123_4042# WL26 VSS VSS sg13_lv_nmos ad=0.102p pd=1.28u as=57f ps=0.68u w=0.3u l=0.13u
X312 BL5 WL0 VSS VSS sg13_lv_nmos ad=0.102p pd=1.28u as=0.114p ps=1.36u w=0.3u l=0.13u
X313 VSS WL59 BL3 VSS sg13_lv_nmos ad=57f pd=0.68u as=0.102p ps=1.28u w=0.3u l=0.13u
X314 VSS WL3 a_225_480# VSS sg13_lv_nmos ad=57f pd=0.68u as=0.102p ps=1.28u w=0.3u l=0.13u
X315 BL6 WL30 VSS VSS sg13_lv_nmos ad=0.102p pd=1.28u as=57f ps=0.68u w=0.3u l=0.13u
X316 VSS WL1 BL4 VSS sg13_lv_nmos ad=57f pd=0.68u as=0.102p ps=1.28u w=0.3u l=0.13u
X317 BL3 WL30 VSS VSS sg13_lv_nmos ad=0.102p pd=1.28u as=57f ps=0.68u w=0.3u l=0.13u
X318 VSS WL53 a_531_8130# VSS sg13_lv_nmos ad=57f pd=0.68u as=0.102p ps=1.28u w=0.3u l=0.13u
X319 BL0 WL8 VSS VSS sg13_lv_nmos ad=0.102p pd=1.28u as=57f ps=0.68u w=0.3u l=0.13u
X320 VSS WL53 a_225_8130# VSS sg13_lv_nmos ad=57f pd=0.68u as=0.102p ps=1.28u w=0.3u l=0.13u
X321 a_735_9550# WL62 VSS VSS sg13_lv_nmos ad=0.102p pd=1.28u as=57f ps=0.68u w=0.3u l=0.13u
X322 VSS WL1 BL5 VSS sg13_lv_nmos ad=57f pd=0.68u as=0.102p ps=1.28u w=0.3u l=0.13u
X323 VSS WL37 BL6 VSS sg13_lv_nmos ad=57f pd=0.68u as=0.102p ps=1.28u w=0.3u l=0.13u
X324 a_429_9550# WL62 VSS VSS sg13_lv_nmos ad=0.102p pd=1.28u as=57f ps=0.68u w=0.3u l=0.13u
X325 VSS WL51 BL0 VSS sg13_lv_nmos ad=57f pd=0.68u as=0.102p ps=1.28u w=0.3u l=0.13u
X326 VSS WL37 BL3 VSS sg13_lv_nmos ad=57f pd=0.68u as=0.102p ps=1.28u w=0.3u l=0.13u
X327 a_21_982# WL6 VSS VSS sg13_lv_nmos ad=0.102p pd=1.28u as=57f ps=0.68u w=0.3u l=0.13u
X328 BL7 WL6 VSS VSS sg13_lv_nmos ad=0.102p pd=1.28u as=57f ps=0.68u w=0.3u l=0.13u
X329 VSS WL63 a_123_9660# VSS sg13_lv_nmos ad=0.114p pd=1.36u as=0.102p ps=1.28u w=0.3u l=0.13u
X330 VSS WL27 BL1 VSS sg13_lv_nmos ad=57f pd=0.68u as=0.102p ps=1.28u w=0.3u l=0.13u
X331 a_735_8632# WL56 VSS VSS sg13_lv_nmos ad=0.102p pd=1.28u as=57f ps=0.68u w=0.3u l=0.13u
X332 VSS WL31 a_633_4764# VSS sg13_lv_nmos ad=57f pd=0.68u as=0.102p ps=1.28u w=0.3u l=0.13u
X333 a_429_8632# WL56 VSS VSS sg13_lv_nmos ad=0.102p pd=1.28u as=57f ps=0.68u w=0.3u l=0.13u
X334 VSS WL15 a_735_2316# VSS sg13_lv_nmos ad=57f pd=0.68u as=0.102p ps=1.28u w=0.3u l=0.13u
X335 VSS WL31 a_327_4764# VSS sg13_lv_nmos ad=57f pd=0.68u as=0.102p ps=1.28u w=0.3u l=0.13u
X336 VSS WL45 BL0 VSS sg13_lv_nmos ad=57f pd=0.68u as=0.102p ps=1.28u w=0.3u l=0.13u
X337 BL1 WL46 VSS VSS sg13_lv_nmos ad=0.102p pd=1.28u as=57f ps=0.68u w=0.3u l=0.13u
X338 VSS WL15 a_429_2316# VSS sg13_lv_nmos ad=57f pd=0.68u as=0.102p ps=1.28u w=0.3u l=0.13u
X339 VSS WL21 BL1 VSS sg13_lv_nmos ad=57f pd=0.68u as=0.102p ps=1.28u w=0.3u l=0.13u
X340 BL6 WL50 VSS VSS sg13_lv_nmos ad=0.102p pd=1.28u as=57f ps=0.68u w=0.3u l=0.13u
X341 BL3 WL50 VSS VSS sg13_lv_nmos ad=0.102p pd=1.28u as=57f ps=0.68u w=0.3u l=0.13u
X342 VSS WL3 BL3 VSS sg13_lv_nmos ad=57f pd=0.68u as=0.102p ps=1.28u w=0.3u l=0.13u
X343 BL6 WL14 VSS VSS sg13_lv_nmos ad=0.102p pd=1.28u as=57f ps=0.68u w=0.3u l=0.13u
X344 VSS WL25 a_633_3846# VSS sg13_lv_nmos ad=57f pd=0.68u as=0.102p ps=1.28u w=0.3u l=0.13u
X345 BL3 WL14 VSS VSS sg13_lv_nmos ad=0.102p pd=1.28u as=57f ps=0.68u w=0.3u l=0.13u
X346 VSS WL9 a_735_1398# VSS sg13_lv_nmos ad=57f pd=0.68u as=0.102p ps=1.28u w=0.3u l=0.13u
X347 VSS WL25 a_327_3846# VSS sg13_lv_nmos ad=57f pd=0.68u as=0.102p ps=1.28u w=0.3u l=0.13u
X348 BL1 WL40 VSS VSS sg13_lv_nmos ad=0.102p pd=1.28u as=57f ps=0.68u w=0.3u l=0.13u
X349 VSS WL9 a_429_1398# VSS sg13_lv_nmos ad=57f pd=0.68u as=0.102p ps=1.28u w=0.3u l=0.13u
X350 VSS WL19 BL5 VSS sg13_lv_nmos ad=57f pd=0.68u as=0.102p ps=1.28u w=0.3u l=0.13u
X351 a_531_3736# WL24 VSS VSS sg13_lv_nmos ad=0.102p pd=1.28u as=57f ps=0.68u w=0.3u l=0.13u
X352 VSS WL57 a_735_8742# VSS sg13_lv_nmos ad=57f pd=0.68u as=0.102p ps=1.28u w=0.3u l=0.13u
X353 BL6 WL8 VSS VSS sg13_lv_nmos ad=0.102p pd=1.28u as=57f ps=0.68u w=0.3u l=0.13u
X354 a_225_3736# WL24 VSS VSS sg13_lv_nmos ad=0.102p pd=1.28u as=57f ps=0.68u w=0.3u l=0.13u
X355 VSS WL1 a_633_174# VSS sg13_lv_nmos ad=57f pd=0.68u as=0.102p ps=1.28u w=0.3u l=0.13u
X356 VSS WL19 BL2 VSS sg13_lv_nmos ad=57f pd=0.68u as=0.102p ps=1.28u w=0.3u l=0.13u
X357 VSS WL57 a_429_8742# VSS sg13_lv_nmos ad=57f pd=0.68u as=0.102p ps=1.28u w=0.3u l=0.13u
X358 BL3 WL8 VSS VSS sg13_lv_nmos ad=0.102p pd=1.28u as=57f ps=0.68u w=0.3u l=0.13u
X359 VSS WL47 BL1 VSS sg13_lv_nmos ad=57f pd=0.68u as=0.102p ps=1.28u w=0.3u l=0.13u
X360 VSS WL51 BL6 VSS sg13_lv_nmos ad=57f pd=0.68u as=0.102p ps=1.28u w=0.3u l=0.13u
X361 BL1 WL18 VSS VSS sg13_lv_nmos ad=0.102p pd=1.28u as=57f ps=0.68u w=0.3u l=0.13u
X362 VSS WL51 BL3 VSS sg13_lv_nmos ad=57f pd=0.68u as=0.102p ps=1.28u w=0.3u l=0.13u
X363 BL0 WL16 VSS VSS sg13_lv_nmos ad=0.102p pd=1.28u as=57f ps=0.68u w=0.3u l=0.13u
X364 VSS WL41 a_123_6294# VSS sg13_lv_nmos ad=57f pd=0.68u as=0.102p ps=1.28u w=0.3u l=0.13u
X365 BL1 WL12 VSS VSS sg13_lv_nmos ad=0.102p pd=1.28u as=57f ps=0.68u w=0.3u l=0.13u
X366 VSS WL45 BL6 VSS sg13_lv_nmos ad=57f pd=0.68u as=0.102p ps=1.28u w=0.3u l=0.13u
X367 VSS WL3 a_429_480# VSS sg13_lv_nmos ad=57f pd=0.68u as=0.102p ps=1.28u w=0.3u l=0.13u
X368 a_327_64# WL0 VSS VSS sg13_lv_nmos ad=0.102p pd=1.28u as=0.114p ps=1.36u w=0.3u l=0.13u
X369 BL7 WL34 VSS VSS sg13_lv_nmos ad=0.102p pd=1.28u as=57f ps=0.68u w=0.3u l=0.13u
X370 VSS WL39 a_21_5988# VSS sg13_lv_nmos ad=57f pd=0.68u as=0.102p ps=1.28u w=0.3u l=0.13u
X371 VSS WL45 BL3 VSS sg13_lv_nmos ad=57f pd=0.68u as=0.102p ps=1.28u w=0.3u l=0.13u
X372 BL5 WL60 VSS VSS sg13_lv_nmos ad=0.102p pd=1.28u as=57f ps=0.68u w=0.3u l=0.13u
X373 BL0 WL10 VSS VSS sg13_lv_nmos ad=0.102p pd=1.28u as=57f ps=0.68u w=0.3u l=0.13u
X374 BL4 WL34 VSS VSS sg13_lv_nmos ad=0.102p pd=1.28u as=57f ps=0.68u w=0.3u l=0.13u
X375 BL2 WL60 VSS VSS sg13_lv_nmos ad=0.102p pd=1.28u as=57f ps=0.68u w=0.3u l=0.13u
X376 VSS WL35 a_123_5376# VSS sg13_lv_nmos ad=57f pd=0.68u as=0.102p ps=1.28u w=0.3u l=0.13u
X377 a_531_6796# WL44 VSS VSS sg13_lv_nmos ad=0.102p pd=1.28u as=57f ps=0.68u w=0.3u l=0.13u
X378 a_225_6796# WL44 VSS VSS sg13_lv_nmos ad=0.102p pd=1.28u as=57f ps=0.68u w=0.3u l=0.13u
X379 VSS WL3 a_531_480# VSS sg13_lv_nmos ad=57f pd=0.68u as=0.102p ps=1.28u w=0.3u l=0.13u
X380 BL0 WL58 VSS VSS sg13_lv_nmos ad=0.102p pd=1.28u as=57f ps=0.68u w=0.3u l=0.13u
X381 VSS WL1 a_21_174# VSS sg13_lv_nmos ad=57f pd=0.68u as=0.102p ps=1.28u w=0.3u l=0.13u
X382 BL7 WL28 VSS VSS sg13_lv_nmos ad=0.102p pd=1.28u as=57f ps=0.68u w=0.3u l=0.13u
X383 VSS WL33 a_21_5070# VSS sg13_lv_nmos ad=57f pd=0.68u as=0.102p ps=1.28u w=0.3u l=0.13u
X384 VSS WL1 BL7 VSS sg13_lv_nmos ad=57f pd=0.68u as=0.102p ps=1.28u w=0.3u l=0.13u
X385 VSS WL17 BL0 VSS sg13_lv_nmos ad=57f pd=0.68u as=0.102p ps=1.28u w=0.3u l=0.13u
X386 BL4 WL28 VSS VSS sg13_lv_nmos ad=0.102p pd=1.28u as=57f ps=0.68u w=0.3u l=0.13u
X387 VSS WL13 BL5 VSS sg13_lv_nmos ad=57f pd=0.68u as=0.102p ps=1.28u w=0.3u l=0.13u
X388 VSS WL29 a_123_4458# VSS sg13_lv_nmos ad=57f pd=0.68u as=0.102p ps=1.28u w=0.3u l=0.13u
X389 a_531_5878# WL38 VSS VSS sg13_lv_nmos ad=0.102p pd=1.28u as=57f ps=0.68u w=0.3u l=0.13u
X390 VSS WL13 BL2 VSS sg13_lv_nmos ad=57f pd=0.68u as=0.102p ps=1.28u w=0.3u l=0.13u
X391 a_225_5878# WL38 VSS VSS sg13_lv_nmos ad=0.102p pd=1.28u as=57f ps=0.68u w=0.3u l=0.13u
X392 BL7 WL22 VSS VSS sg13_lv_nmos ad=0.102p pd=1.28u as=57f ps=0.68u w=0.3u l=0.13u
X393 VSS WL61 BL5 VSS sg13_lv_nmos ad=57f pd=0.68u as=0.102p ps=1.28u w=0.3u l=0.13u
X394 VSS WL11 BL0 VSS sg13_lv_nmos ad=57f pd=0.68u as=0.102p ps=1.28u w=0.3u l=0.13u
X395 BL4 WL22 VSS VSS sg13_lv_nmos ad=0.102p pd=1.28u as=57f ps=0.68u w=0.3u l=0.13u
X396 VSS WL61 BL2 VSS sg13_lv_nmos ad=57f pd=0.68u as=0.102p ps=1.28u w=0.3u l=0.13u
X397 VSS WL23 a_123_3540# VSS sg13_lv_nmos ad=57f pd=0.68u as=0.102p ps=1.28u w=0.3u l=0.13u
X398 a_531_4960# WL32 VSS VSS sg13_lv_nmos ad=0.102p pd=1.28u as=57f ps=0.68u w=0.3u l=0.13u
X399 BL6 WL16 VSS VSS sg13_lv_nmos ad=0.102p pd=1.28u as=57f ps=0.68u w=0.3u l=0.13u
X400 a_225_4960# WL32 VSS VSS sg13_lv_nmos ad=0.102p pd=1.28u as=57f ps=0.68u w=0.3u l=0.13u
X401 BL3 WL16 VSS VSS sg13_lv_nmos ad=0.102p pd=1.28u as=57f ps=0.68u w=0.3u l=0.13u
X402 VSS WL55 BL5 VSS sg13_lv_nmos ad=57f pd=0.68u as=0.102p ps=1.28u w=0.3u l=0.13u
X403 VSS WL39 a_633_5988# VSS sg13_lv_nmos ad=57f pd=0.68u as=0.102p ps=1.28u w=0.3u l=0.13u
X404 VSS WL55 BL2 VSS sg13_lv_nmos ad=57f pd=0.68u as=0.102p ps=1.28u w=0.3u l=0.13u
X405 VSS WL53 BL0 VSS sg13_lv_nmos ad=57f pd=0.68u as=0.102p ps=1.28u w=0.3u l=0.13u
X406 BL7 WL48 VSS VSS sg13_lv_nmos ad=0.102p pd=1.28u as=57f ps=0.68u w=0.3u l=0.13u
X407 VSS WL39 a_327_5988# VSS sg13_lv_nmos ad=57f pd=0.68u as=0.102p ps=1.28u w=0.3u l=0.13u
X408 BL6 WL10 VSS VSS sg13_lv_nmos ad=0.102p pd=1.28u as=57f ps=0.68u w=0.3u l=0.13u
X409 BL4 WL48 VSS VSS sg13_lv_nmos ad=0.102p pd=1.28u as=57f ps=0.68u w=0.3u l=0.13u
X410 VSS WL3 BL6 VSS sg13_lv_nmos ad=57f pd=0.68u as=0.102p ps=1.28u w=0.3u l=0.13u
X411 BL3 WL10 VSS VSS sg13_lv_nmos ad=0.102p pd=1.28u as=57f ps=0.68u w=0.3u l=0.13u
X412 BL1 WL54 VSS VSS sg13_lv_nmos ad=0.102p pd=1.28u as=57f ps=0.68u w=0.3u l=0.13u
X413 VSS WL49 BL1 VSS sg13_lv_nmos ad=57f pd=0.68u as=0.102p ps=1.28u w=0.3u l=0.13u
X414 a_123_370# WL2 VSS VSS sg13_lv_nmos ad=0.102p pd=1.28u as=57f ps=0.68u w=0.3u l=0.13u
X415 VSS WL33 a_633_5070# VSS sg13_lv_nmos ad=57f pd=0.68u as=0.102p ps=1.28u w=0.3u l=0.13u
X416 BL6 WL58 VSS VSS sg13_lv_nmos ad=0.102p pd=1.28u as=57f ps=0.68u w=0.3u l=0.13u
X417 BL3 WL58 VSS VSS sg13_lv_nmos ad=0.102p pd=1.28u as=57f ps=0.68u w=0.3u l=0.13u
X418 VSS WL33 a_327_5070# VSS sg13_lv_nmos ad=57f pd=0.68u as=0.102p ps=1.28u w=0.3u l=0.13u
X419 BL7 WL42 VSS VSS sg13_lv_nmos ad=0.102p pd=1.28u as=57f ps=0.68u w=0.3u l=0.13u
X420 VSS WL17 BL6 VSS sg13_lv_nmos ad=57f pd=0.68u as=0.102p ps=1.28u w=0.3u l=0.13u
X421 VSS WL17 BL3 VSS sg13_lv_nmos ad=57f pd=0.68u as=0.102p ps=1.28u w=0.3u l=0.13u
X422 BL4 WL42 VSS VSS sg13_lv_nmos ad=0.102p pd=1.28u as=57f ps=0.68u w=0.3u l=0.13u
X423 BL5 WL52 VSS VSS sg13_lv_nmos ad=0.102p pd=1.28u as=57f ps=0.68u w=0.3u l=0.13u
X424 VSS WL43 BL1 VSS sg13_lv_nmos ad=57f pd=0.68u as=0.102p ps=1.28u w=0.3u l=0.13u
X425 VSS WL7 BL1 VSS sg13_lv_nmos ad=57f pd=0.68u as=0.102p ps=1.28u w=0.3u l=0.13u
X426 BL2 WL52 VSS VSS sg13_lv_nmos ad=0.102p pd=1.28u as=57f ps=0.68u w=0.3u l=0.13u
X427 a_735_5572# WL36 VSS VSS sg13_lv_nmos ad=0.102p pd=1.28u as=57f ps=0.68u w=0.3u l=0.13u
X428 VSS WL11 BL6 VSS sg13_lv_nmos ad=57f pd=0.68u as=0.102p ps=1.28u w=0.3u l=0.13u
X429 VSS WL11 BL3 VSS sg13_lv_nmos ad=57f pd=0.68u as=0.102p ps=1.28u w=0.3u l=0.13u
X430 a_429_5572# WL36 VSS VSS sg13_lv_nmos ad=0.102p pd=1.28u as=57f ps=0.68u w=0.3u l=0.13u
X431 a_531_4042# WL26 VSS VSS sg13_lv_nmos ad=0.102p pd=1.28u as=57f ps=0.68u w=0.3u l=0.13u
X432 VSS WL59 a_735_9048# VSS sg13_lv_nmos ad=57f pd=0.68u as=0.102p ps=1.28u w=0.3u l=0.13u
X433 a_225_4042# WL26 VSS VSS sg13_lv_nmos ad=0.102p pd=1.28u as=57f ps=0.68u w=0.3u l=0.13u
X434 VSS WL59 a_429_9048# VSS sg13_lv_nmos ad=57f pd=0.68u as=0.102p ps=1.28u w=0.3u l=0.13u
X435 VSS WL3 BL0 VSS sg13_lv_nmos ad=57f pd=0.68u as=0.102p ps=1.28u w=0.3u l=0.13u
X436 a_735_4654# WL30 VSS VSS sg13_lv_nmos ad=0.102p pd=1.28u as=57f ps=0.68u w=0.3u l=0.13u
X437 VSS WL3 a_735_480# VSS sg13_lv_nmos ad=57f pd=0.68u as=0.102p ps=1.28u w=0.3u l=0.13u
X438 VSS WL19 a_21_2928# VSS sg13_lv_nmos ad=57f pd=0.68u as=0.102p ps=1.28u w=0.3u l=0.13u
X439 BL0 WL24 VSS VSS sg13_lv_nmos ad=0.102p pd=1.28u as=57f ps=0.68u w=0.3u l=0.13u
X440 a_429_4654# WL30 VSS VSS sg13_lv_nmos ad=0.102p pd=1.28u as=57f ps=0.68u w=0.3u l=0.13u
X441 VSS WL53 BL6 VSS sg13_lv_nmos ad=57f pd=0.68u as=0.102p ps=1.28u w=0.3u l=0.13u
X442 a_123_3124# WL20 VSS VSS sg13_lv_nmos ad=0.102p pd=1.28u as=57f ps=0.68u w=0.3u l=0.13u
X443 VSS WL53 BL3 VSS sg13_lv_nmos ad=57f pd=0.68u as=0.102p ps=1.28u w=0.3u l=0.13u
X444 a_225_370# WL2 VSS VSS sg13_lv_nmos ad=0.102p pd=1.28u as=57f ps=0.68u w=0.3u l=0.13u
X445 VSS WL37 a_735_5682# VSS sg13_lv_nmos ad=57f pd=0.68u as=0.102p ps=1.28u w=0.3u l=0.13u
X446 VSS WL63 a_531_9660# VSS sg13_lv_nmos ad=0.114p pd=1.36u as=0.102p ps=1.28u w=0.3u l=0.13u
X447 VSS WL37 a_429_5682# VSS sg13_lv_nmos ad=57f pd=0.68u as=0.102p ps=1.28u w=0.3u l=0.13u
X448 VSS WL27 BL5 VSS sg13_lv_nmos ad=57f pd=0.68u as=0.102p ps=1.28u w=0.3u l=0.13u
X449 VSS WL63 a_225_9660# VSS sg13_lv_nmos ad=0.114p pd=1.36u as=0.102p ps=1.28u w=0.3u l=0.13u
X450 VSS WL27 BL2 VSS sg13_lv_nmos ad=57f pd=0.68u as=0.102p ps=1.28u w=0.3u l=0.13u
X451 VSS WL31 BL7 VSS sg13_lv_nmos ad=57f pd=0.68u as=0.102p ps=1.28u w=0.3u l=0.13u
X452 BL5 WL46 VSS VSS sg13_lv_nmos ad=0.102p pd=1.28u as=57f ps=0.68u w=0.3u l=0.13u
X453 a_123_9550# WL62 VSS VSS sg13_lv_nmos ad=0.102p pd=1.28u as=57f ps=0.68u w=0.3u l=0.13u
X454 VSS WL31 BL4 VSS sg13_lv_nmos ad=57f pd=0.68u as=0.102p ps=1.28u w=0.3u l=0.13u
X455 VSS WL21 BL5 VSS sg13_lv_nmos ad=57f pd=0.68u as=0.102p ps=1.28u w=0.3u l=0.13u
X456 BL2 WL46 VSS VSS sg13_lv_nmos ad=0.102p pd=1.28u as=57f ps=0.68u w=0.3u l=0.13u
X457 a_21_9244# WL60 VSS VSS sg13_lv_nmos ad=0.102p pd=1.28u as=57f ps=0.68u w=0.3u l=0.13u
X458 a_735_7714# WL50 VSS VSS sg13_lv_nmos ad=0.102p pd=1.28u as=57f ps=0.68u w=0.3u l=0.13u
X459 VSS WL21 BL2 VSS sg13_lv_nmos ad=57f pd=0.68u as=0.102p ps=1.28u w=0.3u l=0.13u
X460 a_735_2206# WL14 VSS VSS sg13_lv_nmos ad=0.102p pd=1.28u as=57f ps=0.68u w=0.3u l=0.13u
X461 a_429_7714# WL50 VSS VSS sg13_lv_nmos ad=0.102p pd=1.28u as=57f ps=0.68u w=0.3u l=0.13u
X462 VSS WL25 BL7 VSS sg13_lv_nmos ad=57f pd=0.68u as=0.102p ps=1.28u w=0.3u l=0.13u
X463 BL0 WL44 VSS VSS sg13_lv_nmos ad=0.102p pd=1.28u as=57f ps=0.68u w=0.3u l=0.13u
X464 BL5 WL40 VSS VSS sg13_lv_nmos ad=0.102p pd=1.28u as=57f ps=0.68u w=0.3u l=0.13u
X465 a_123_8632# WL56 VSS VSS sg13_lv_nmos ad=0.102p pd=1.28u as=57f ps=0.68u w=0.3u l=0.13u
X466 a_429_2206# WL14 VSS VSS sg13_lv_nmos ad=0.102p pd=1.28u as=57f ps=0.68u w=0.3u l=0.13u
X467 VSS WL25 BL4 VSS sg13_lv_nmos ad=57f pd=0.68u as=0.102p ps=1.28u w=0.3u l=0.13u
X468 VSS WL15 a_123_2316# VSS sg13_lv_nmos ad=57f pd=0.68u as=0.102p ps=1.28u w=0.3u l=0.13u
X469 BL2 WL40 VSS VSS sg13_lv_nmos ad=0.102p pd=1.28u as=57f ps=0.68u w=0.3u l=0.13u
X470 BL3 WL2 VSS VSS sg13_lv_nmos ad=0.102p pd=1.28u as=57f ps=0.68u w=0.3u l=0.13u
X471 BL6 WL24 VSS VSS sg13_lv_nmos ad=0.102p pd=1.28u as=57f ps=0.68u w=0.3u l=0.13u
X472 VSS WL19 a_633_2928# VSS sg13_lv_nmos ad=57f pd=0.68u as=0.102p ps=1.28u w=0.3u l=0.13u
X473 VSS WL13 a_21_2010# VSS sg13_lv_nmos ad=57f pd=0.68u as=0.102p ps=1.28u w=0.3u l=0.13u
X474 a_735_1288# WL8 VSS VSS sg13_lv_nmos ad=0.102p pd=1.28u as=57f ps=0.68u w=0.3u l=0.13u
X475 VSS WL19 a_327_2928# VSS sg13_lv_nmos ad=57f pd=0.68u as=0.102p ps=1.28u w=0.3u l=0.13u
X476 BL3 WL24 VSS VSS sg13_lv_nmos ad=0.102p pd=1.28u as=57f ps=0.68u w=0.3u l=0.13u
X477 BL0 WL38 VSS VSS sg13_lv_nmos ad=0.102p pd=1.28u as=57f ps=0.68u w=0.3u l=0.13u
X478 VSS WL47 BL5 VSS sg13_lv_nmos ad=57f pd=0.68u as=0.102p ps=1.28u w=0.3u l=0.13u
X479 a_429_1288# WL8 VSS VSS sg13_lv_nmos ad=0.102p pd=1.28u as=57f ps=0.68u w=0.3u l=0.13u
X480 VSS WL47 BL2 VSS sg13_lv_nmos ad=57f pd=0.68u as=0.102p ps=1.28u w=0.3u l=0.13u
X481 VSS WL9 a_123_1398# VSS sg13_lv_nmos ad=57f pd=0.68u as=0.102p ps=1.28u w=0.3u l=0.13u
X482 BL5 WL18 VSS VSS sg13_lv_nmos ad=0.102p pd=1.28u as=57f ps=0.68u w=0.3u l=0.13u
X483 VSS WL61 a_21_9354# VSS sg13_lv_nmos ad=57f pd=0.68u as=0.102p ps=1.28u w=0.3u l=0.13u
X484 VSS WL51 a_735_7824# VSS sg13_lv_nmos ad=57f pd=0.68u as=0.102p ps=1.28u w=0.3u l=0.13u
X485 BL2 WL18 VSS VSS sg13_lv_nmos ad=0.102p pd=1.28u as=57f ps=0.68u w=0.3u l=0.13u
X486 VSS WL51 a_429_7824# VSS sg13_lv_nmos ad=57f pd=0.68u as=0.102p ps=1.28u w=0.3u l=0.13u
X487 BL7 WL0 VSS VSS sg13_lv_nmos ad=0.102p pd=1.28u as=0.114p ps=1.36u w=0.3u l=0.13u
X488 BL0 WL32 VSS VSS sg13_lv_nmos ad=0.102p pd=1.28u as=57f ps=0.68u w=0.3u l=0.13u
X489 VSS WL41 a_531_6294# VSS sg13_lv_nmos ad=57f pd=0.68u as=0.102p ps=1.28u w=0.3u l=0.13u
X490 VSS WL57 a_123_8742# VSS sg13_lv_nmos ad=57f pd=0.68u as=0.102p ps=1.28u w=0.3u l=0.13u
X491 VSS WL5 a_123_786# VSS sg13_lv_nmos ad=57f pd=0.68u as=0.102p ps=1.28u w=0.3u l=0.13u
X492 VSS WL41 a_225_6294# VSS sg13_lv_nmos ad=57f pd=0.68u as=0.102p ps=1.28u w=0.3u l=0.13u
X493 BL5 WL12 VSS VSS sg13_lv_nmos ad=0.102p pd=1.28u as=57f ps=0.68u w=0.3u l=0.13u
X494 VSS WL55 a_21_8436# VSS sg13_lv_nmos ad=57f pd=0.68u as=0.102p ps=1.28u w=0.3u l=0.13u
X495 BL2 WL12 VSS VSS sg13_lv_nmos ad=0.102p pd=1.28u as=57f ps=0.68u w=0.3u l=0.13u
X496 VSS WL45 a_735_6906# VSS sg13_lv_nmos ad=57f pd=0.68u as=0.102p ps=1.28u w=0.3u l=0.13u
X497 VSS WL45 a_429_6906# VSS sg13_lv_nmos ad=57f pd=0.68u as=0.102p ps=1.28u w=0.3u l=0.13u
X498 a_633_9244# WL60 VSS VSS sg13_lv_nmos ad=0.102p pd=1.28u as=57f ps=0.68u w=0.3u l=0.13u
X499 VSS WL35 a_531_5376# VSS sg13_lv_nmos ad=57f pd=0.68u as=0.102p ps=1.28u w=0.3u l=0.13u
X500 a_327_9244# WL60 VSS VSS sg13_lv_nmos ad=0.102p pd=1.28u as=57f ps=0.68u w=0.3u l=0.13u
X501 VSS WL35 a_225_5376# VSS sg13_lv_nmos ad=57f pd=0.68u as=0.102p ps=1.28u w=0.3u l=0.13u
X502 BL6 WL44 VSS VSS sg13_lv_nmos ad=0.102p pd=1.28u as=57f ps=0.68u w=0.3u l=0.13u
X503 a_429_370# WL2 VSS VSS sg13_lv_nmos ad=0.102p pd=1.28u as=57f ps=0.68u w=0.3u l=0.13u
X504 a_21_64# WL0 VSS VSS sg13_lv_nmos ad=0.102p pd=1.28u as=0.114p ps=1.36u w=0.3u l=0.13u
X505 BL3 WL44 VSS VSS sg13_lv_nmos ad=0.102p pd=1.28u as=57f ps=0.68u w=0.3u l=0.13u
X506 VSS WL29 a_531_4458# VSS sg13_lv_nmos ad=57f pd=0.68u as=0.102p ps=1.28u w=0.3u l=0.13u
X507 BL1 WL34 VSS VSS sg13_lv_nmos ad=0.102p pd=1.28u as=57f ps=0.68u w=0.3u l=0.13u
X508 VSS WL13 a_633_2010# VSS sg13_lv_nmos ad=57f pd=0.68u as=0.102p ps=1.28u w=0.3u l=0.13u
X509 VSS WL29 a_225_4458# VSS sg13_lv_nmos ad=57f pd=0.68u as=0.102p ps=1.28u w=0.3u l=0.13u
X510 BL6 WL38 VSS VSS sg13_lv_nmos ad=0.102p pd=1.28u as=57f ps=0.68u w=0.3u l=0.13u
X511 a_531_370# WL2 VSS VSS sg13_lv_nmos ad=0.102p pd=1.28u as=57f ps=0.68u w=0.3u l=0.13u
C0 a_735_3736# BL7 0.08359f
C1 a_21_6490# WL43 0
C2 a_327_6490# WL42 0.00259f
C3 BL4 WL14 0.00158f
C4 BL2 WL1 0.00428f
C5 BL6 a_633_174# 0.01064f
C6 a_429_8938# WL58 0.00259f
C7 a_225_9048# BL3 0.0809f
C8 a_21_5070# BL0 0.08359f
C9 a_633_2928# WL19 0.00259f
C10 BL3 a_429_9550# 0.0809f
C11 a_225_3124# BL1 0
C12 a_735_8742# WL56 0
C13 BL0 WL10 0.00508f
C14 a_531_9550# BL6 0.0809f
C15 BL7 WL40 0.00497f
C16 BL7 WL5 0.00233f
C17 BL1 a_123_8632# 0.01064f
C18 BL6 WL33 0.00169f
C19 WL59 WL60 0.08922f
C20 a_327_3430# WL23 0
C21 a_429_6796# WL44 0.00259f
C22 a_531_2206# WL15 0
C23 a_429_2622# WL16 0
C24 a_21_1900# WL13 0
C25 a_225_4042# BL1 0
C26 BL4 a_327_982# 0.0809f
C27 WL21 WL22 0.08922f
C28 BL0 WL29 0.00497f
C29 a_225_5376# BL2 0.08359f
C30 BL4 WL22 0.00417f
C31 a_633_982# WL6 0.00259f
C32 a_531_1594# BL4 0
C33 a_429_9660# a_429_9550# 0.07294f
C34 BL3 a_225_370# 0.0809f
C35 a_123_2206# WL14 0.00259f
C36 BL5 WL32 0.00169f
C37 BL1 WL52 0.00417f
C38 WL16 a_123_2622# 0
C39 BL1 a_123_2622# 0.01064f
C40 BL7 WL21 0.00497f
C41 BL3 WL1 0.00158f
C42 WL62 WL63 0.03692f
C43 a_21_8326# BL0 0.01064f
C44 a_123_4458# WL28 0
C45 BL7 WL48 0.00508f
C46 BL4 WL58 0.00158f
C47 a_633_8326# a_633_8436# 0.07294f
C48 BL7 WL26 0.00233f
C49 BL2 WL32 0.00169f
C50 a_327_8436# WL54 0
C51 a_735_2206# WL14 0.00275f
C52 a_429_1594# BL4 0.01064f
C53 a_225_1398# BL2 0.01064f
C54 BL4 WL51 0.00158f
C55 BL1 WL3 0.00158f
C56 BL6 a_531_1704# 0.0809f
C57 a_123_4654# BL2 0
C58 BL6 WL24 0.00417f
C59 BL4 a_531_8130# 0
C60 BL5 WL12 0.00428f
C61 a_735_8742# BL7 0.01064f
C62 WL54 BL4 0.00428f
C63 a_225_1398# a_123_1398# 0.08068f
C64 a_633_676# BL7 0.0809f
C65 a_225_3540# WL22 0
C66 a_225_5376# BL3 0.0809f
C67 a_531_2622# a_531_2512# 0.07294f
C68 a_225_8938# WL58 0.00259f
C69 BL5 WL43 0.00428f
C70 a_327_174# a_327_64# 0.07294f
C71 BL2 WL12 0.00428f
C72 a_735_5878# BL7 0.08359f
C73 BL2 a_327_4764# 0.0809f
C74 BL4 WL9 0.00158f
C75 BL0 WL4 0.00233f
C76 a_531_2622# BL5 0.01064f
C77 BL0 WL30 0.00497f
C78 WL37 WL38 0.08922f
C79 a_21_8436# WL54 0
C80 a_123_4960# WL32 0.00259f
C81 a_633_4152# BL7 0.0809f
C82 BL1 WL0 0.00428f
C83 a_633_8326# BL6 0.01064f
C84 a_123_5682# WL37 0.00259f
C85 BL2 WL43 0.00428f
C86 a_123_1288# WL8 0.00259f
C87 a_123_9048# BL2 0
C88 BL4 a_429_8130# 0.08359f
C89 BL3 WL32 0.00417f
C90 a_225_3736# WL24 0.00259f
C91 a_225_1398# BL3 0.0809f
C92 a_225_5878# WL38 0.00259f
C93 BL7 a_735_2206# 0.01064f
C94 WL61 BL7 0.00508f
C95 a_21_9244# WL60 0.00275f
C96 WL6 a_327_982# 0.00259f
C97 BL1 WL56 0.00158f
C98 BL5 WL18 0.00428f
C99 BL1 a_123_370# 0.01064f
C100 a_21_174# BL0 0.01064f
C101 a_123_1594# WL10 0.00259f
C102 BL1 WL14 0.00158f
C103 a_429_9048# a_429_8938# 0.07294f
C104 a_633_3846# WL24 0
C105 BL1 a_21_8020# 0.0809f
C106 a_735_8632# WL56 0.00275f
C107 BL0 a_123_6906# 0.0809f
C108 BL3 WL12 0.00158f
C109 a_531_8632# WL56 0.00259f
C110 BL3 a_327_4764# 0.08359f
C111 BL2 WL18 0.00428f
C112 a_531_9550# BL4 0
C113 WL39 a_429_5878# 0
C114 a_123_8938# WL58 0.00259f
C115 WL30 WL31 0.03692f
C116 BL4 WL33 0.00417f
C117 BL3 WL43 0.00158f
C118 a_735_3736# WL24 0.00275f
C119 BL7 WL6 0.00508f
C120 WL60 a_21_9354# 0
C121 a_735_2512# BL7 0.01064f
C122 a_531_6294# BL5 0.08359f
C123 BL7 WL41 0.00233f
C124 BL1 WL22 0.00417f
C125 a_633_4764# WL30 0
C126 a_429_4960# WL33 0
C127 a_531_1594# WL11 0
C128 BL6 WL31 0.00169f
C129 a_429_1398# a_531_1398# 0.08068f
C130 a_21_7212# WL46 0
C131 a_531_2316# a_531_2206# 0.07294f
C132 BL7 a_633_1900# 0.0809f
C133 a_429_9048# BL4 0.01064f
C134 a_123_8742# BL0 0.0809f
C135 BL7 WL16 0.00222f
C136 BL7 WL11 0.00222f
C137 BL6 a_633_4764# 0.08359f
C138 BL1 WL58 0.00158f
C139 BL3 WL18 0.00158f
C140 a_429_1594# WL11 0
C141 WL44 WL45 0.03692f
C142 BL1 WL51 0.00158f
C143 BL5 WL44 0.00158f
C144 WL29 a_531_4458# 0.00259f
C145 BL5 a_633_3234# 0.0809f
C146 BL1 a_225_8632# 0
C147 a_735_8632# BL7 0.01064f
C148 BL7 WL25 0.00497f
C149 BL4 a_531_1704# 0
C150 BL4 WL24 0.00169f
C151 a_327_2818# a_327_2928# 0.07294f
C152 a_531_6796# WL44 0.00259f
C153 WL54 BL1 0.00428f
C154 BL6 WL42 0.00158f
C155 a_21_2010# WL12 0
C156 BL2 WL44 0.00158f
C157 BL0 WL40 0.00233f
C158 BL0 WL5 0.00497f
C159 WL26 a_21_4152# 0
C160 a_735_2512# a_735_2622# 0.07294f
C161 BL4 a_327_2818# 0.0809f
C162 BL1 WL9 0.00158f
C163 WL60 a_327_9354# 0
C164 BL5 a_531_786# 0.08359f
C165 a_123_4042# BL2 0
C166 BL5 WL34 0.00417f
C167 a_225_2206# WL15 0
C168 a_531_3736# BL5 0.08359f
C169 BL5 WL47 0.00428f
C170 a_633_2928# BL7 0.0809f
C171 a_531_5572# BL6 0.0809f
C172 WL59 BL7 0.00222f
C173 BL0 WL21 0.00233f
C174 BL2 WL34 0.00417f
C175 WL59 WL58 0.03692f
C176 a_225_2316# WL15 0.00259f
C177 a_735_2622# WL16 0
C178 WL35 a_633_5266# 0
C179 a_327_3430# WL22 0.00259f
C180 a_531_9048# WL58 0
C181 a_531_6906# WL44 0
C182 BL7 WL62 0.00222f
C183 a_633_7518# BL5 0.0809f
C184 BL0 WL48 0.00222f
C185 a_429_3124# a_531_3124# 0.08068f
C186 a_123_2512# a_123_2622# 0.07294f
C187 BL2 WL47 0.00428f
C188 BL7 WL35 0.00233f
C189 BL0 WL26 0.00497f
C190 a_225_1288# BL1 0
C191 BL3 WL44 0.00428f
C192 BL5 WL57 0.00158f
C193 a_21_8436# BL0 0.01064f
C194 a_21_1092# WL7 0.00275f
C195 a_633_6600# a_633_6490# 0.07294f
C196 BL2 a_123_2316# 0
C197 WL53 a_633_8020# 0
C198 a_225_8130# BL1 0
C199 BL2 WL57 0.00158f
C200 BL1 WL33 0.00417f
C201 a_633_6600# BL7 0.0809f
C202 a_225_9660# BL1 0
C203 a_327_8436# a_327_8326# 0.07294f
C204 WL8 a_531_1398# 0
C205 BL6 a_531_4458# 0.0809f
C206 a_531_4960# BL5 0.08359f
C207 WL29 WL30 0.08922f
C208 a_123_5878# WL39 0
C209 BL3 WL34 0.00169f
C210 a_123_2206# BL0 0.0809f
C211 a_327_1900# WL12 0.00259f
C212 BL6 a_633_7212# 0.01064f
C213 BL6 WL10 0.00428f
C214 BL4 WL31 0.00417f
C215 BL4 a_327_8326# 0.0809f
C216 BL2 a_327_7212# 0.0809f
C217 a_327_64# WL0 0.00259f
C218 BL3 WL47 0.00158f
C219 BL1 a_123_8130# 0.08359f
C220 BL1 a_21_5266# 0.0809f
C221 WL20 a_21_3234# 0
C222 BL6 WL29 0.00417f
C223 BL5 WL27 0.00417f
C224 BL0 WL61 0.00222f
C225 a_123_5376# BL1 0.08359f
C226 WL21 a_327_3234# 0.00259f
C227 BL4 a_327_6490# 0.0809f
C228 BL3 WL57 0.00428f
C229 BL4 a_327_3234# 0.0809f
C230 a_429_8632# WL56 0.00259f
C231 a_735_2316# BL6 0.0809f
C232 BL5 a_633_64# 0.0809f
C233 BL2 WL27 0.00417f
C234 a_531_7714# a_429_7714# 0.08068f
C235 a_327_1092# BL4 0.0809f
C236 BL6 a_531_3124# 0.0809f
C237 WL11 a_531_1704# 0.00259f
C238 BL1 WL24 0.00169f
C239 a_531_9550# WL62 0.00259f
C240 BL4 WL42 0.00428f
C241 BL1 a_21_4152# 0.0809f
C242 BL0 a_123_8938# 0.0809f
C243 BL5 a_429_5878# 0
C244 WL43 a_327_6600# 0.00259f
C245 BL2 a_123_480# 0
C246 a_633_7518# WL49 0.00259f
C247 a_225_9660# WL62 0
C248 BL0 WL6 0.00222f
C249 BL7 a_735_6906# 0.01064f
C250 WL25 WL24 0.03692f
C251 BL3 a_327_7212# 0.01064f
C252 WL53 a_327_8020# 0
C253 BL0 WL41 0.00497f
C254 a_225_5682# BL2 0.01064f
C255 BL4 a_327_7102# 0.0809f
C256 BL0 a_21_4348# 0.08359f
C257 a_531_370# BL5 0.01064f
C258 a_327_4348# BL2 0.0809f
C259 a_429_1398# WL9 0.00259f
C260 BL6 a_633_8436# 0.01064f
C261 a_633_3234# WL20 0
C262 a_429_9048# WL59 0.00259f
C263 a_735_4458# WL29 0.00275f
C264 a_531_5572# BL4 0
C265 a_531_9048# a_429_9048# 0.08068f
C266 BL3 WL27 0.00169f
C267 BL0 WL16 0.00508f
C268 BL6 WL4 0.00169f
C269 BL0 WL11 0.00508f
C270 BL6 WL30 0.00417f
C271 a_21_5266# WL35 0
C272 a_225_4458# a_123_4458# 0.08068f
C273 BL0 BL1 11.3838f
C274 a_429_2622# WL17 0.00259f
C275 a_531_1288# BL6 0.0809f
C276 a_123_5376# WL35 0.00259f
C277 BL0 WL25 0.00233f
C278 a_327_5070# WL33 0.00259f
C279 a_123_9660# BL1 0.01064f
C280 a_735_6796# WL44 0.00275f
C281 a_21_2928# WL19 0.00275f
C282 a_225_5682# BL3 0.0809f
C283 a_225_5682# WL36 0
C284 BL3 a_429_5878# 0.0809f
C285 BL6 a_735_1398# 0.0809f
C286 WL53 WL52 0.03692f
C287 BL5 WL39 0.00417f
C288 a_225_2622# a_123_2622# 0.08068f
C289 a_327_4348# BL3 0.08359f
C290 a_327_7518# BL2 0.0809f
C291 WL17 a_123_2622# 0.00259f
C292 a_633_2818# BL5 0.0809f
C293 a_21_7102# WL47 0
C294 a_429_6906# WL44 0
C295 a_225_786# WL4 0
C296 BL4 a_531_4458# 0
C297 a_735_5682# a_735_5572# 0.07294f
C298 BL2 WL39 0.00417f
C299 a_429_6796# WL45 0
C300 a_429_2206# BL5 0
C301 a_225_1704# WL10 0
C302 BL5 a_429_6796# 0
C303 a_327_1092# WL6 0
C304 BL4 WL10 0.00158f
C305 BL1 WL31 0.00417f
C306 WL15 WL14 0.03692f
C307 a_225_8742# WL57 0.00259f
C308 a_225_370# a_225_480# 0.07294f
C309 BL7 a_735_8938# 0.01064f
C310 a_735_9660# BL6 0.0809f
C311 BL7 WL8 0.00222f
C312 a_735_8938# WL58 0.00275f
C313 BL0 WL59 0.00508f
C314 a_531_6796# a_429_6796# 0.08068f
C315 BL7 a_735_6294# 0.08359f
C316 WL41 WL42 0.08922f
C317 BL4 WL29 0.00169f
C318 a_327_5988# WL38 0
C319 BL0 WL62 0.00508f
C320 WL28 WL27 0.08922f
C321 a_429_3124# WL21 0
C322 a_531_7714# BL5 0.01064f
C323 a_633_982# WL7 0
C324 BL0 WL35 0.00497f
C325 BL4 a_429_3124# 0.08359f
C326 a_735_5682# WL36 0
C327 WL21 a_531_3124# 0
C328 BL6 a_531_480# 0.0809f
C329 a_327_7518# BL3 0.01064f
C330 a_633_3846# BL6 0.08359f
C331 WL55 WL56 0.08922f
C332 BL6 a_735_4458# 0.0809f
C333 BL4 a_531_3124# 0
C334 a_123_9660# WL62 0
C335 WL4 WL5 0.03692f
C336 a_531_8938# BL5 0.01064f
C337 BL3 WL39 0.00169f
C338 BL1 WL42 0.00428f
C339 a_327_174# WL1 0.00259f
C340 WL9 WL8 0.03692f
C341 a_735_3736# BL6 0.0809f
C342 a_327_4348# WL28 0.00259f
C343 a_531_4042# WL27 0
C344 a_633_7408# BL7 0.0809f
C345 a_633_2010# BL5 0.0809f
C346 a_429_2206# BL3 0.0809f
C347 BL6 a_531_8742# 0.0809f
C348 a_21_8436# a_21_8326# 0.07294f
C349 BL7 WL15 0.00222f
C350 a_429_7714# BL5 0
C351 BL3 a_429_6796# 0.0809f
C352 a_429_5376# WL34 0
C353 BL6 WL5 0.00417f
C354 a_123_6796# WL44 0.00259f
C355 WL53 a_21_8020# 0
C356 BL6 WL40 0.00169f
C357 a_123_1594# BL1 0.01064f
C358 a_123_1594# WL11 0
C359 a_327_7518# WL49 0.00259f
C360 a_21_7518# WL49 0.00275f
C361 a_123_5878# BL2 0
C362 WL63 a_225_9550# 0
C363 BL4 WL4 0.00417f
C364 a_225_1288# WL8 0.00259f
C365 a_735_9550# WL63 0
C366 a_633_9354# a_633_9244# 0.07294f
C367 a_225_5682# WL37 0.00259f
C368 BL4 WL30 0.00169f
C369 WL12 WL13 0.03692f
C370 a_429_8742# WL57 0.00259f
C371 a_123_3124# BL2 0
C372 a_531_1288# BL4 0
C373 a_735_2316# a_735_2206# 0.07294f
C374 WL53 a_735_8130# 0.00275f
C375 BL7 WL55 0.00508f
C376 WL50 a_735_7714# 0.00275f
C377 BL6 WL21 0.00169f
C378 a_633_676# WL4 0.00259f
C379 a_225_786# WL5 0.00259f
C380 a_225_370# WL2 0.00259f
C381 WL7 a_327_982# 0
C382 BL6 WL48 0.00158f
C383 a_21_9244# BL0 0.01064f
C384 BL6 WL26 0.00417f
C385 a_633_9354# WL60 0
C386 a_429_9550# WL63 0
C387 WL53 BL7 0.00233f
C388 a_21_4348# WL29 0
C389 a_735_5376# BL7 0.08359f
C390 WL1 WL2 0.08922f
C391 a_21_1092# a_21_982# 0.07294f
C392 WL23 a_735_3540# 0.00275f
C393 WL54 WL55 0.03692f
C394 a_429_7714# BL3 0.0809f
C395 BL7 WL17 0.00222f
C396 a_735_8742# BL6 0.0809f
C397 a_21_5070# BL1 0.0809f
C398 BL6 a_633_676# 0.08359f
C399 a_531_7714# WL50 0.00259f
C400 BL1 WL10 0.00158f
C401 WL11 WL10 0.03692f
C402 a_735_5682# WL37 0.00275f
C403 a_633_6600# WL42 0
C404 BL7 WL7 0.00508f
C405 WL53 a_531_8130# 0.00259f
C406 a_735_5878# BL6 0.0809f
C407 WL53 WL54 0.08922f
C408 a_21_1900# BL0 0.01064f
C409 BL0 a_21_9354# 0.01064f
C410 a_327_6184# WL40 0.00259f
C411 BL1 WL29 0.00169f
C412 a_225_6906# a_123_6906# 0.08068f
C413 a_633_4152# BL6 0.08359f
C414 a_123_5572# BL0 0.0809f
C415 BL4 a_531_480# 0
C416 BL1 a_225_4960# 0
C417 a_531_2316# WL14 0
C418 a_123_2512# BL0 0.0809f
C419 BL5 a_531_2512# 0.01064f
C420 a_429_7714# WL50 0.00259f
C421 a_21_8326# BL1 0.0809f
C422 a_225_5878# WL39 0
C423 WL53 a_429_8130# 0.00259f
C424 BL5 WL45 0.00158f
C425 BL6 a_735_2206# 0.0809f
C426 BL6 WL61 0.00158f
C427 a_429_2316# WL14 0
C428 BL1 a_225_5572# 0
C429 a_531_6796# WL45 0
C430 a_225_7714# BL2 0.01064f
C431 BL4 a_429_8938# 0.01064f
C432 BL2 WL45 0.00158f
C433 a_327_6184# BL4 0.0809f
C434 a_735_2622# WL17 0.00275f
C435 BL4 a_531_8742# 0
C436 BL5 a_531_6796# 0.01064f
C437 a_225_7714# a_123_7714# 0.08068f
C438 a_327_2010# BL4 0.0809f
C439 a_429_2512# a_531_2512# 0.08068f
C440 WL40 a_429_6294# 0
C441 BL4 WL40 0.00417f
C442 BL4 WL5 0.00169f
C443 a_633_5070# BL7 0.0809f
C444 a_21_7212# BL0 0.01064f
C445 a_429_2512# BL5 0
C446 BL0 WL8 0.00508f
C447 WL53 a_225_8130# 0.00259f
C448 BL6 WL6 0.00158f
C449 BL6 WL41 0.00417f
C450 a_735_2512# BL6 0.0809f
C451 BL1 WL4 0.00417f
C452 a_21_5988# BL0 0.08359f
C453 BL1 WL30 0.00169f
C454 BL2 a_123_1398# 0
C455 BL2 a_123_9550# 0
C456 BL2 a_123_7714# 0
C457 a_327_8436# BL4 0.0809f
C458 a_633_676# WL5 0
C459 a_429_6796# a_429_6906# 0.07294f
C460 a_225_370# WL3 0
C461 a_531_6906# WL45 0.00259f
C462 BL4 a_327_2928# 0.0809f
C463 a_225_7714# BL3 0.0809f
C464 BL4 WL21 0.00417f
C465 a_531_3736# a_429_3736# 0.08068f
C466 BL5 a_531_6906# 0.01064f
C467 BL6 a_633_1900# 0.01064f
C468 BL4 a_429_6294# 0.08359f
C469 BL3 WL45 0.00428f
C470 BL6 WL11 0.00428f
C471 BL6 WL16 0.00428f
C472 WL53 a_123_8130# 0.00259f
C473 BL5 WL36 0.00158f
C474 BL2 a_123_4960# 0
C475 BL4 WL48 0.00428f
C476 BL4 WL26 0.00169f
C477 a_531_6906# a_531_6796# 0.07294f
C478 a_633_5988# WL38 0
C479 a_123_3124# WL20 0.00259f
C480 a_21_174# BL1 0.0809f
C481 BL6 a_735_8632# 0.0809f
C482 a_225_5878# a_123_5878# 0.08068f
C483 a_531_8632# BL6 0.0809f
C484 BL1 a_123_6906# 0.01064f
C485 BL2 WL36 0.00158f
C486 a_225_2512# WL16 0.00259f
C487 BL3 BL2 11.3838f
C488 a_123_786# BL0 0.0809f
C489 BL6 WL25 0.00169f
C490 a_225_2512# BL1 0
C491 WL18 WL19 0.03692f
C492 BL0 WL15 0.00508f
C493 a_225_1594# BL2 0.01064f
C494 a_429_4960# BL4 0.08359f
C495 WL1 WL0 0.03692f
C496 a_531_3540# BL5 0.08359f
C497 a_429_2512# BL3 0.0809f
C498 a_429_9660# BL5 0
C499 WL36 a_735_5572# 0.00275f
C500 a_633_8326# WL55 0
C501 a_225_3736# BL1 0
C502 BL5 WL49 0.00428f
C503 a_225_7714# WL50 0.00259f
C504 a_225_786# BL1 0
C505 a_327_676# WL4 0.00259f
C506 a_735_9550# BL7 0.01064f
C507 a_225_370# a_123_370# 0.08068f
C508 BL5 WL50 0.00158f
C509 a_633_4152# WL26 0
C510 BL2 WL49 0.00428f
C511 a_327_6184# WL41 0
C512 a_225_3736# WL25 0
C513 BL7 WL38 0.00233f
C514 a_633_5070# WL33 0.00259f
C515 WL6 WL5 0.08922f
C516 a_531_2622# a_429_2622# 0.08068f
C517 BL0 WL55 0.00222f
C518 a_633_2928# BL6 0.01064f
C519 BL4 a_429_370# 0.01064f
C520 a_429_4042# BL4 0.08359f
C521 WL59 BL6 0.00428f
C522 WL40 WL41 0.03692f
C523 a_123_8742# BL1 0.01064f
C524 BL2 WL50 0.00158f
C525 a_531_9048# BL6 0.0809f
C526 a_429_4042# WL26 0.00259f
C527 WL61 BL4 0.00428f
C528 a_531_9660# BL5 0.01064f
C529 BL6 WL62 0.00428f
C530 a_225_1594# BL3 0.0809f
C531 BL3 WL36 0.00428f
C532 BL6 WL35 0.00417f
C533 a_225_9048# WL58 0
C534 a_429_1288# WL9 0
C535 WL50 a_123_7714# 0.00259f
C536 a_633_3846# WL25 0.00259f
C537 WL53 BL0 0.00497f
C538 BL5 WL28 0.00417f
C539 a_429_2206# a_531_2206# 0.08068f
C540 BL0 WL17 0.00508f
C541 BL2 WL28 0.00417f
C542 BL1 WL40 0.00417f
C543 a_735_3736# WL25 0
C544 BL1 WL5 0.00169f
C545 a_633_6600# BL6 0.01064f
C546 a_633_1092# BL5 0.0809f
C547 a_735_7824# a_735_7714# 0.07294f
C548 a_429_9660# BL3 0.0809f
C549 BL0 WL7 0.00222f
C550 BL4 WL6 0.00428f
C551 a_531_8632# a_531_8742# 0.07294f
C552 WL41 a_429_6294# 0.00259f
C553 BL3 WL49 0.00158f
C554 a_735_9660# WL62 0
C555 BL4 WL41 0.00169f
C556 a_633_9354# BL7 0.0809f
C557 WL47 WL46 0.03692f
C558 WL22 a_735_3540# 0
C559 WL55 a_327_8326# 0
C560 BL5 WL20 0.00169f
C561 BL0 a_123_6294# 0.0809f
C562 BL5 WL37 0.00158f
C563 a_531_4042# BL5 0.08359f
C564 BL7 WL1 0.00508f
C565 BL3 WL50 0.00428f
C566 WL23 a_21_3430# 0
C567 a_225_8938# a_123_8938# 0.08068f
C568 a_225_1704# WL11 0.00259f
C569 a_225_8742# BL2 0.01064f
C570 a_123_480# a_225_480# 0.08068f
C571 a_225_1704# BL1 0
C572 a_327_9244# BL2 0.0809f
C573 BL2 WL20 0.00169f
C574 a_735_4042# WL27 0
C575 BL1 WL21 0.00417f
C576 BL2 WL37 0.00158f
C577 BL4 WL16 0.00158f
C578 BL7 a_735_3540# 0.08359f
C579 BL4 WL11 0.00158f
C580 BL0 a_123_1704# 0.0809f
C581 a_225_9660# a_225_9550# 0.07294f
C582 BL1 WL48 0.00428f
C583 BL1 WL26 0.00169f
C584 BL3 WL28 0.00169f
C585 a_225_2316# a_123_2316# 0.08068f
C586 WL59 a_429_8938# 0
C587 a_735_6796# WL45 0
C588 WL37 a_735_5572# 0
C589 a_327_3846# WL24 0
C590 BL2 a_225_6294# 0.08359f
C591 a_531_4654# BL5 0.08359f
C592 a_123_5572# a_225_5572# 0.08068f
C593 a_531_8632# BL4 0
C594 BL4 WL25 0.00417f
C595 WL50 WL49 0.08922f
C596 a_225_5878# BL2 0.08359f
C597 a_21_8436# BL1 0.0809f
C598 WL25 WL26 0.08922f
C599 BL1 a_225_6906# 0
C600 a_327_7212# WL46 0
C601 a_429_9660# a_531_9660# 0.08068f
C602 a_225_4654# WL31 0
C603 a_225_8938# BL1 0
C604 a_429_6906# WL45 0.00259f
C605 a_429_786# a_531_786# 0.08068f
C606 a_327_676# WL5 0
C607 BL5 a_429_6906# 0
C608 a_531_7714# a_531_7824# 0.07294f
C609 a_735_9048# BL7 0.01064f
C610 BL6 a_735_6906# 0.0809f
C611 a_735_9048# WL58 0
C612 a_21_2928# BL0 0.01064f
C613 a_21_7408# BL0 0.01064f
C614 a_531_9550# a_429_9550# 0.08068f
C615 a_735_8742# a_735_8632# 0.07294f
C616 BL7 WL32 0.00233f
C617 a_225_8742# BL3 0.0809f
C618 a_327_1900# BL2 0.0809f
C619 a_327_9244# BL3 0.01064f
C620 BL3 WL20 0.00417f
C621 WL37 WL36 0.03692f
C622 BL3 WL37 0.00428f
C623 a_225_3540# BL1 0
C624 a_429_480# BL5 0
C625 a_123_2206# BL1 0.01064f
C626 a_225_4042# a_123_4042# 0.08068f
C627 a_327_1092# WL7 0.00259f
C628 BL7 a_735_4960# 0.08359f
C629 WL59 BL4 0.00158f
C630 a_633_174# WL1 0.00259f
C631 a_225_5878# BL3 0.0809f
C632 BL3 a_225_6294# 0.0809f
C633 a_531_9048# BL4 0
C634 a_429_8742# BL5 0
C635 BL1 WL61 0.00428f
C636 BL4 WL62 0.00158f
C637 a_123_3736# WL24 0.00259f
C638 BL7 WL12 0.00508f
C639 BL4 WL35 0.00169f
C640 BL4 a_327_676# 0.0809f
C641 a_429_5376# BL5 0
C642 a_633_6490# WL43 0
C643 a_429_7714# a_429_7824# 0.07294f
C644 BL7 WL43 0.00508f
C645 a_225_1398# WL9 0.00259f
C646 BL2 a_327_6600# 0.0809f
C647 a_225_8938# WL59 0
C648 a_327_3430# BL4 0.0809f
C649 a_735_1594# BL7 0.01064f
C650 a_123_9048# WL58 0
C651 a_531_6906# a_429_6906# 0.08068f
C652 a_123_8632# WL57 0
C653 a_327_1900# BL3 0.01064f
C654 a_123_8938# BL1 0.01064f
C655 BL5 a_633_4348# 0.0809f
C656 BL3 a_429_6906# 0.0809f
C657 BL1 WL6 0.00428f
C658 a_123_480# WL2 0
C659 a_225_2512# a_123_2512# 0.08068f
C660 a_735_2316# WL15 0.00275f
C661 a_21_2818# WL19 0
C662 a_123_6796# WL45 0
C663 a_735_2512# WL16 0.00275f
C664 BL1 WL41 0.00169f
C665 BL1 a_21_4348# 0.0809f
C666 a_429_480# BL3 0.0809f
C667 BL0 a_123_4458# 0.0809f
C668 a_531_1288# WL8 0.00259f
C669 a_123_3736# BL0 0.0809f
C670 a_123_5682# BL0 0.0809f
C671 BL0 WL38 0.00497f
C672 BL6 a_735_8938# 0.0809f
C673 a_123_1594# a_123_1704# 0.07294f
C674 a_225_1398# a_225_1288# 0.07294f
C675 BL2 a_123_6796# 0
C676 BL7 WL18 0.00508f
C677 a_531_370# WL2 0.00259f
C678 BL4 a_327_5070# 0.0809f
C679 a_429_8742# BL3 0.0809f
C680 BL6 a_735_6294# 0.0809f
C681 BL6 WL8 0.00428f
C682 a_735_1398# WL8 0
C683 a_633_2010# WL13 0.00259f
C684 BL1 WL16 0.00158f
C685 a_327_5988# WL39 0.00259f
C686 WL61 WL62 0.08922f
C687 BL1 WL11 0.00158f
C688 BL5 a_531_2206# 0.01064f
C689 BL3 a_327_6600# 0.01064f
C690 a_633_7102# WL47 0
C691 WL32 WL33 0.03692f
C692 BL5 a_429_4654# 0
C693 a_429_5376# BL3 0.0809f
C694 a_429_1398# BL4 0.01064f
C695 a_225_6796# a_225_6906# 0.07294f
C696 a_21_8326# WL55 0
C697 BL1 WL25 0.00417f
C698 a_123_786# WL4 0
C699 a_123_8938# WL59 0
C700 a_225_5376# a_123_5376# 0.08068f
C701 a_735_1288# BL7 0.01064f
C702 a_735_4960# WL33 0
C703 a_225_4042# WL27 0
C704 a_633_7408# BL6 0.01064f
C705 WL55 a_633_8436# 0.00259f
C706 BL6 WL15 0.00428f
C707 BL5 a_429_1704# 0
C708 BL0 WL1 0.00222f
C709 a_633_2818# WL19 0
C710 a_735_1288# WL9 0
C711 WL10 a_123_1704# 0
C712 BL7 a_735_786# 0.08359f
C713 WL59 BL1 0.00158f
C714 a_531_7824# BL5 0.01064f
C715 BL7 WL44 0.00222f
C716 BL7 a_633_3234# 0.0809f
C717 BL1 WL62 0.00158f
C718 a_429_7824# BL5 0
C719 a_123_2316# WL14 0
C720 WL56 WL57 0.03692f
C721 a_225_7714# a_225_7824# 0.07294f
C722 BL3 a_429_4654# 0.0809f
C723 BL1 WL35 0.00169f
C724 a_429_8632# BL4 0.01064f
C725 a_531_5376# BL6 0.0809f
C726 BL4 a_327_64# 0.0809f
C727 a_123_480# WL3 0.00259f
C728 WL22 a_21_3430# 0.00275f
C729 BL6 WL55 0.00158f
C730 a_123_786# a_225_786# 0.08068f
C731 a_735_6294# WL40 0
C732 a_633_5266# WL34 0.00259f
C733 a_225_7824# BL2 0.01064f
C734 a_21_64# WL0 0.00275f
C735 BL0 a_21_6600# 0.01064f
C736 BL7 WL34 0.00497f
C737 a_21_9244# WL61 0
C738 WL28 a_633_4348# 0.00259f
C739 a_429_3736# BL5 0
C740 WL53 BL6 0.00417f
C741 a_735_5376# BL6 0.0809f
C742 BL7 WL47 0.00508f
C743 a_735_480# WL2 0
C744 a_225_4654# WL30 0.00259f
C745 BL0 WL32 0.00497f
C746 BL6 WL17 0.00428f
C747 a_633_64# WL0 0.00259f
C748 a_531_370# WL3 0
C749 BL3 a_429_1704# 0.0809f
C750 a_633_7518# BL7 0.0809f
C751 BL5 WL13 0.00428f
C752 BL0 a_21_982# 0.01064f
C753 a_225_2512# a_225_2622# 0.07294f
C754 a_123_4654# BL0 0.0809f
C755 BL1 a_225_6796# 0
C756 a_531_9048# WL59 0.00259f
C757 a_735_7824# WL50 0
C758 BL6 WL7 0.00158f
C759 BL4 WL8 0.00158f
C760 a_225_2512# WL17 0
C761 WL61 a_21_9354# 0.00275f
C762 BL7 WL57 0.00222f
C763 a_123_786# WL5 0.00259f
C764 WL57 WL58 0.08922f
C765 BL3 a_429_7824# 0.0809f
C766 BL2 WL13 0.00428f
C767 BL0 WL12 0.00222f
C768 BL4 a_327_9354# 0.0809f
C769 a_225_8632# WL57 0
C770 a_225_7824# BL3 0.0809f
C771 a_123_370# a_123_480# 0.07294f
C772 a_633_6184# BL5 0.0809f
C773 a_123_1288# BL2 0
C774 BL0 WL43 0.00222f
C775 a_123_9048# BL0 0.0809f
C776 BL2 a_225_480# 0.01064f
C777 a_429_5682# BL5 0
C778 a_327_2818# WL18 0.00259f
C779 a_123_1288# a_123_1398# 0.07294f
C780 BL2 a_225_4458# 0.08359f
C781 WL31 WL32 0.08922f
C782 a_21_9244# BL1 0.0809f
C783 a_429_3736# BL3 0.0809f
C784 a_531_7824# WL50 0
C785 a_123_4654# WL31 0
C786 a_123_7824# BL2 0
C787 a_633_7408# WL48 0.00259f
C788 a_123_4458# WL29 0.00259f
C789 BL4 WL15 0.00158f
C790 a_123_7824# a_123_7714# 0.07294f
C791 a_429_7824# WL50 0
C792 BL7 WL27 0.00497f
C793 a_327_174# BL2 0.0809f
C794 BL3 WL13 0.00158f
C795 a_633_5070# BL6 0.08359f
C796 a_21_6600# WL42 0
C797 a_225_7824# WL50 0
C798 BL0 WL18 0.00222f
C799 WL31 a_327_4764# 0.00259f
C800 WL33 WL34 0.08922f
C801 a_21_1900# BL1 0.0809f
C802 BL1 a_21_9354# 0.0809f
C803 BL7 a_633_64# 0.0809f
C804 a_123_3124# a_225_3124# 0.08068f
C805 a_633_8020# BL5 0.0809f
C806 a_327_8436# WL55 0.00259f
C807 BL3 a_225_480# 0.0809f
C808 WL61 a_327_9354# 0.00259f
C809 BL0 a_21_3234# 0.08359f
C810 a_735_3124# WL20 0.00275f
C811 BL3 a_225_4458# 0.0809f
C812 WL46 WL45 0.08922f
C813 a_531_2316# BL6 0.0809f
C814 a_123_5572# BL1 0.01064f
C815 a_531_5878# BL6 0.0809f
C816 a_531_5376# BL4 0
C817 BL5 WL46 0.00428f
C818 a_123_2512# WL16 0.00259f
C819 BL4 a_327_4152# 0.0809f
C820 a_429_5682# WL36 0
C821 a_429_5682# BL3 0.0809f
C822 BL4 WL55 0.00428f
C823 a_531_4654# a_429_4654# 0.08068f
C824 a_633_9244# BL5 0.0809f
C825 a_327_5988# BL2 0.0809f
C826 a_123_2512# BL1 0.01064f
C827 WL26 a_327_4152# 0
C828 a_735_480# WL3 0.00275f
C829 a_531_8632# a_429_8632# 0.08068f
C830 a_327_6490# WL43 0
C831 a_123_2206# WL15 0
C832 BL5 WL23 0.00169f
C833 a_21_5266# WL34 0.00275f
C834 BL2 WL46 0.00428f
C835 a_123_6294# WL40 0
C836 a_225_2206# BL2 0.01064f
C837 BL3 a_327_174# 0.01064f
C838 a_735_6294# WL41 0.00275f
C839 a_21_8436# WL55 0.00275f
C840 a_123_5376# WL34 0
C841 a_633_5988# WL39 0.00259f
C842 a_123_3540# BL2 0
C843 a_429_2206# WL14 0.00259f
C844 WL53 BL4 0.00169f
C845 BL2 WL23 0.00169f
C846 BL4 WL17 0.00158f
C847 WL42 WL43 0.03692f
C848 a_735_2206# WL15 0
C849 BL5 WL2 0.00158f
C850 BL5 WL19 0.00428f
C851 a_225_2316# BL2 0.01064f
C852 a_735_1704# BL7 0.01064f
C853 BL5 WL60 0.00428f
C854 a_531_1288# a_429_1288# 0.08068f
C855 a_531_4960# WL33 0
C856 a_531_3736# WL24 0.00259f
C857 BL4 WL7 0.00428f
C858 WL48 a_327_7408# 0.00259f
C859 a_429_5572# BL5 0
C860 a_21_7212# BL1 0.0809f
C861 BL5 a_531_5682# 0.01064f
C862 BL4 a_327_7408# 0.0809f
C863 a_21_2010# WL13 0.00275f
C864 a_735_5682# BL7 0.01064f
C865 BL1 WL8 0.00158f
C866 BL2 WL2 0.00158f
C867 BL2 WL19 0.00428f
C868 BL0 WL44 0.00508f
C869 a_21_5988# BL1 0.0809f
C870 BL2 WL60 0.00428f
C871 a_327_5988# BL3 0.08359f
C872 a_123_7824# WL50 0
C873 a_735_9550# BL6 0.0809f
C874 BL0 a_21_676# 0.08359f
C875 BL5 WL63 0.00158f
C876 BL3 WL46 0.00158f
C877 a_633_174# a_633_64# 0.07294f
C878 BL6 WL38 0.00417f
C879 BL7 WL39 0.00497f
C880 a_225_2206# BL3 0.0809f
C881 a_123_4042# BL0 0.0809f
C882 a_225_4458# WL28 0
C883 BL5 a_429_786# 0
C884 a_429_3540# BL5 0
C885 a_21_5070# WL32 0
C886 a_633_2818# BL7 0.0809f
C887 a_225_1704# a_123_1704# 0.08068f
C888 BL2 WL63 0.00158f
C889 BL3 WL23 0.00417f
C890 BL7 a_735_7714# 0.01064f
C891 a_225_2316# BL3 0.0809f
C892 BL2 a_327_8020# 0.0809f
C893 BL0 WL34 0.00233f
C894 a_735_7714# WL51 0
C895 a_735_9550# a_735_9660# 0.07294f
C896 WL63 a_123_9550# 0
C897 BL0 WL47 0.00222f
C898 BL0 a_21_3430# 0.08359f
C899 BL3 WL19 0.00158f
C900 a_123_786# BL1 0.08359f
C901 BL3 WL2 0.00428f
C902 a_123_3736# a_225_3736# 0.08068f
C903 WL16 WL15 0.08922f
C904 BL1 WL15 0.00158f
C905 WL59 a_735_8938# 0
C906 BL3 WL60 0.00158f
C907 a_429_2622# BL5 0
C908 a_531_3540# WL23 0.00259f
C909 a_225_3124# BL2 0.08359f
C910 BL2 a_123_8632# 0
C911 WL36 a_531_5682# 0
C912 a_429_5572# WL36 0.00259f
C913 a_225_4960# WL32 0.00259f
C914 a_429_5572# BL3 0.0809f
C915 BL0 a_123_2316# 0.0809f
C916 a_429_5682# WL37 0.00259f
C917 BL5 a_531_1398# 0.01064f
C918 a_21_7408# WL48 0.00275f
C919 BL0 WL57 0.00508f
C920 a_633_9354# BL6 0.01064f
C921 a_531_7714# WL51 0
C922 a_225_4042# BL2 0.08359f
C923 a_735_1594# WL10 0.00275f
C924 a_531_2316# BL4 0
C925 BL5 WL52 0.00417f
C926 BL7 a_735_480# 0.01064f
C927 a_531_5878# BL4 0
C928 BL6 WL1 0.00158f
C929 BL3 WL63 0.00428f
C930 a_429_2512# a_429_2622# 0.07294f
C931 WL27 a_21_4152# 0.00275f
C932 a_429_3540# BL3 0.0809f
C933 a_735_2512# WL17 0
C934 a_531_8938# WL58 0.00259f
C935 BL3 a_327_8020# 0.08359f
C936 a_21_174# WL1 0.00275f
C937 a_327_1900# WL13 0
C938 BL3 a_429_786# 0.0809f
C939 BL1 WL55 0.00428f
C940 a_327_3846# BL4 0.0809f
C941 BL2 a_123_2622# 0
C942 BL4 a_429_2316# 0.01064f
C943 BL2 WL52 0.00417f
C944 a_633_2010# BL7 0.0809f
C945 WL7 WL6 0.03692f
C946 BL6 a_735_3540# 0.0809f
C947 BL5 WL3 0.00158f
C948 a_21_9244# a_21_9354# 0.07294f
C949 a_633_982# BL5 0.0809f
C950 a_225_3124# BL3 0.0809f
C951 BL1 a_225_2622# 0
C952 a_429_3540# a_531_3540# 0.08068f
C953 WL53 BL1 0.00169f
C954 WL16 a_225_2622# 0
C955 a_429_7714# WL51 0
C956 a_429_9660# WL63 0.00259f
C957 WL17 WL16 0.03692f
C958 BL2 WL3 0.00158f
C959 a_123_6294# WL41 0.00259f
C960 BL1 WL17 0.00158f
C961 BL3 a_429_2622# 0.0809f
C962 BL5 a_633_7102# 0.0809f
C963 a_225_4042# BL3 0.0809f
C964 BL0 WL27 0.00233f
C965 BL0 a_21_64# 0.01064f
C966 a_123_4654# WL30 0.00259f
C967 a_735_370# a_735_480# 0.07294f
C968 BL5 WL0 0.00428f
C969 BL6 a_735_9048# 0.0809f
C970 BL1 WL7 0.00428f
C971 a_21_7102# WL46 0.00275f
C972 BL4 a_429_1288# 0.01064f
C973 BL1 a_225_4654# 0
C974 BL3 WL52 0.00169f
C975 BL6 WL32 0.00417f
C976 BL0 a_123_480# 0.0809f
C977 a_21_2818# BL0 0.01064f
C978 a_531_9660# WL63 0.00259f
C979 BL1 a_123_6294# 0.08359f
C980 BL2 WL0 0.00428f
C981 a_429_1398# WL8 0
C982 WL30 a_327_4764# 0
C983 BL4 a_327_5266# 0.0809f
C984 BL4 WL38 0.00169f
C985 BL5 WL56 0.00158f
C986 BL6 a_735_4960# 0.0809f
C987 a_327_7102# WL47 0
C988 a_531_5376# WL35 0.00259f
C989 WL20 WL19 0.08922f
C990 a_429_4458# BL5 0
C991 a_327_9244# WL60 0.00259f
C992 BL3 WL3 0.00428f
C993 BL5 WL14 0.00158f
C994 WL37 a_531_5682# 0.00259f
C995 BL1 a_123_1704# 0.01064f
C996 WL11 a_123_1704# 0.00259f
C997 BL2 WL56 0.00158f
C998 BL6 WL12 0.00158f
C999 a_429_5572# WL37 0
C1000 a_633_5988# BL5 0.0809f
C1001 BL4 a_429_9550# 0.01064f
C1002 BL2 WL14 0.00158f
C1003 BL2 a_123_370# 0
C1004 a_735_5376# WL35 0.00275f
C1005 BL6 WL43 0.00158f
C1006 a_735_5878# WL38 0.00275f
C1007 a_735_1594# BL6 0.0809f
C1008 a_531_2622# BL6 0.0809f
C1009 a_531_7824# a_429_7824# 0.08068f
C1010 BL3 WL0 0.00158f
C1011 a_225_8938# a_225_9048# 0.07294f
C1012 a_21_2928# BL1 0.0809f
C1013 a_21_7408# BL1 0.0809f
C1014 BL5 WL22 0.00417f
C1015 a_633_3430# BL5 0.0809f
C1016 a_531_1594# BL5 0.01064f
C1017 a_327_7212# a_327_7102# 0.07294f
C1018 BL2 a_327_982# 0.0809f
C1019 BL5 a_633_6490# 0.0809f
C1020 BL2 WL22 0.00417f
C1021 BL4 WL1 0.00428f
C1022 BL5 a_633_5266# 0.0809f
C1023 BL7 WL45 0.00222f
C1024 a_21_7518# BL0 0.01064f
C1025 BL0 WL39 0.00233f
C1026 a_225_3124# WL20 0.00259f
C1027 BL6 WL18 0.00158f
C1028 BL3 a_429_4458# 0.0809f
C1029 BL3 WL56 0.00428f
C1030 a_225_7714# WL51 0
C1031 BL5 WL58 0.00158f
C1032 a_429_1594# BL5 0
C1033 BL3 WL14 0.00428f
C1034 a_429_480# WL2 0
C1035 a_633_7212# WL47 0.00259f
C1036 BL5 WL51 0.00158f
C1037 BL2 WL58 0.00158f
C1038 a_327_3846# WL25 0.00259f
C1039 a_531_8130# BL5 0.08359f
C1040 WL54 BL5 0.00428f
C1041 BL2 WL51 0.00158f
C1042 BL2 a_225_8632# 0.01064f
C1043 a_735_1288# BL6 0.0809f
C1044 a_735_1288# a_735_1398# 0.07294f
C1045 a_531_6294# BL6 0.0809f
C1046 BL3 a_327_982# 0.01064f
C1047 a_123_7714# WL51 0
C1048 BL7 a_735_5572# 0.01064f
C1049 a_633_982# a_633_1092# 0.07294f
C1050 a_327_2010# WL12 0
C1051 BL5 WL9 0.00158f
C1052 WL54 BL2 0.00428f
C1053 BL3 WL22 0.00169f
C1054 WL4 a_735_786# 0
C1055 BL2 WL9 0.00158f
C1056 a_633_9354# WL61 0.00259f
C1057 BL1 a_225_9550# 0
C1058 BL4 WL32 0.00169f
C1059 BL5 a_429_8130# 0
C1060 WL4 a_21_676# 0.00275f
C1061 BL1 a_123_4458# 0.08359f
C1062 a_123_3736# BL1 0.08359f
C1063 WL9 a_123_1398# 0.00259f
C1064 BL7 WL36 0.00222f
C1065 BL1 WL38 0.00169f
C1066 a_123_5682# BL1 0.01064f
C1067 BL3 WL58 0.00428f
C1068 a_531_3540# WL22 0
C1069 BL6 a_735_786# 0.0809f
C1070 a_429_1594# BL3 0.0809f
C1071 a_429_4960# WL32 0.00259f
C1072 BL3 WL51 0.00428f
C1073 BL3 a_225_8632# 0.0809f
C1074 BL6 WL44 0.00428f
C1075 BL6 a_633_3234# 0.08359f
C1076 a_429_4458# WL28 0
C1077 WL4 a_531_786# 0
C1078 a_123_3736# WL25 0
C1079 a_123_5878# BL0 0.0809f
C1080 BL5 a_633_174# 0.0809f
C1081 a_123_7824# a_225_7824# 0.08068f
C1082 BL4 WL12 0.00428f
C1083 a_225_9048# BL1 0
C1084 BL4 a_327_4764# 0.0809f
C1085 a_225_1288# BL2 0.01064f
C1086 BL3 WL54 0.00158f
C1087 a_531_9550# BL5 0.01064f
C1088 a_123_6906# WL44 0
C1089 BL5 WL33 0.00417f
C1090 BL4 WL43 0.00428f
C1091 a_123_3124# BL0 0.0809f
C1092 BL0 a_21_4764# 0.08359f
C1093 BL7 WL49 0.00508f
C1094 BL3 WL9 0.00428f
C1095 a_531_2622# BL4 0
C1096 BL6 a_531_786# 0.0809f
C1097 a_225_8130# BL2 0.08359f
C1098 a_123_2512# WL17 0
C1099 BL6 WL34 0.00169f
C1100 BL7 WL50 0.00222f
C1101 BL2 WL33 0.00417f
C1102 BL0 a_21_6490# 0.01064f
C1103 a_225_8742# WL56 0
C1104 a_225_9660# BL2 0.01064f
C1105 WL62 a_225_9550# 0.00259f
C1106 a_531_3736# BL6 0.0809f
C1107 a_225_370# BL1 0
C1108 BL6 WL47 0.00158f
C1109 BL3 a_429_8130# 0.0809f
C1110 a_735_9550# WL62 0.00275f
C1111 a_531_6294# WL40 0
C1112 WL18 a_327_2928# 0
C1113 WL50 WL51 0.03692f
C1114 a_429_480# WL3 0.00259f
C1115 a_429_9048# BL5 0
C1116 BL1 WL1 0.00428f
C1117 a_633_7518# BL6 0.01064f
C1118 BL4 WL18 0.00428f
C1119 a_327_4348# WL29 0
C1120 a_327_5266# WL35 0
C1121 a_225_1288# BL3 0.0809f
C1122 BL7 WL28 0.00497f
C1123 BL2 a_123_8130# 0
C1124 a_225_9048# WL59 0.00259f
C1125 BL6 WL57 0.00428f
C1126 WL21 a_21_3234# 0.00275f
C1127 a_123_4960# WL33 0
C1128 a_21_4764# WL31 0.00275f
C1129 BL5 WL24 0.00169f
C1130 a_735_1704# WL10 0
C1131 a_123_5376# BL2 0
C1132 BL5 a_531_1704# 0.01064f
C1133 a_429_9550# WL62 0.00259f
C1134 a_225_8130# BL3 0.0809f
C1135 a_633_1092# BL7 0.0809f
C1136 a_225_5376# BL1 0
C1137 a_225_5682# a_225_5572# 0.07294f
C1138 a_735_786# WL5 0.00275f
C1139 BL3 WL33 0.00169f
C1140 a_531_6294# a_429_6294# 0.08068f
C1141 a_21_982# WL6 0.00275f
C1142 a_531_6294# BL4 0
C1143 a_225_9660# BL3 0.0809f
C1144 BL2 WL24 0.00169f
C1145 WL7 WL8 0.08922f
C1146 BL6 a_531_4960# 0.0809f
C1147 BL7 WL20 0.00233f
C1148 BL1 a_21_6600# 0.0809f
C1149 BL7 WL37 0.00222f
C1150 WL5 a_21_676# 0
C1151 a_633_8326# BL5 0.0809f
C1152 BL2 a_327_2818# 0.0809f
C1153 a_225_8742# a_225_8632# 0.07294f
C1154 BL1 WL32 0.00169f
C1155 a_123_9048# a_123_8938# 0.07294f
C1156 BL7 a_735_4654# 0.08359f
C1157 a_429_9048# BL3 0.0809f
C1158 a_225_1398# BL1 0
C1159 a_429_1398# a_429_1288# 0.07294f
C1160 a_429_8742# WL56 0
C1161 WL5 a_531_786# 0.00259f
C1162 BL6 WL27 0.00169f
C1163 BL0 WL45 0.00508f
C1164 BL1 a_21_982# 0.0809f
C1165 a_21_174# a_21_64# 0.07294f
C1166 a_123_4654# BL1 0.08359f
C1167 a_633_3234# WL21 0.00259f
C1168 a_123_8742# WL57 0.00259f
C1169 a_21_6490# WL42 0.00275f
C1170 BL4 WL44 0.00158f
C1171 BL6 a_633_64# 0.01064f
C1172 a_735_6796# BL7 0.01064f
C1173 WL12 a_633_1900# 0.00259f
C1174 BL3 WL24 0.00417f
C1175 BL1 WL12 0.00428f
C1176 WL12 WL11 0.08922f
C1177 a_531_9550# a_531_9660# 0.07294f
C1178 BL0 a_123_7714# 0.0809f
C1179 BL0 a_123_9550# 0.0809f
C1180 a_531_8742# WL57 0.00259f
C1181 BL0 a_123_1398# 0.0809f
C1182 a_123_4042# WL26 0.00259f
C1183 a_225_5376# WL35 0.00259f
C1184 BL1 WL43 0.00428f
C1185 BL3 a_327_2818# 0.01064f
C1186 a_225_6906# WL44 0
C1187 a_123_9048# BL1 0.01064f
C1188 a_225_480# WL2 0
C1189 WL59 a_735_9048# 0.00275f
C1190 a_735_1594# WL11 0
C1191 a_531_2622# WL16 0
C1192 BL4 a_531_786# 0
C1193 a_123_9660# BL2 0
C1194 a_531_370# BL6 0.0809f
C1195 BL4 WL34 0.00417f
C1196 a_123_9660# a_123_9550# 0.07294f
C1197 a_531_3736# BL4 0
C1198 BL5 WL31 0.00417f
C1199 BL0 a_123_4960# 0.0809f
C1200 BL4 WL47 0.00428f
C1201 WL48 WL47 0.08922f
C1202 a_429_5682# a_429_5572# 0.07294f
C1203 a_429_5682# a_531_5682# 0.08068f
C1204 a_735_1704# BL6 0.0809f
C1205 BL0 WL36 0.00508f
C1206 WL17 a_225_2622# 0.00259f
C1207 a_633_7518# WL48 0
C1208 BL2 WL31 0.00417f
C1209 BL1 WL18 0.00428f
C1210 a_531_6294# WL41 0.00259f
C1211 BL2 a_327_8326# 0.0809f
C1212 BL5 a_633_4764# 0.0809f
C1213 a_531_2206# WL14 0.00259f
C1214 a_735_5682# BL6 0.0809f
C1215 a_123_5572# a_123_5682# 0.07294f
C1216 BL4 WL57 0.00158f
C1217 BL1 a_21_3234# 0.0809f
C1218 BL2 a_327_6490# 0.0809f
C1219 BL7 a_633_4348# 0.0809f
C1220 a_123_9048# WL59 0.00259f
C1221 BL2 a_327_3234# 0.0809f
C1222 BL6 WL39 0.00169f
C1223 a_531_370# a_531_480# 0.07294f
C1224 BL5 WL42 0.00428f
C1225 a_225_2316# a_225_2206# 0.07294f
C1226 a_735_8742# WL57 0.00275f
C1227 BL0 WL49 0.00222f
C1228 a_633_2818# BL6 0.01064f
C1229 a_327_1092# BL2 0.0809f
C1230 a_123_3540# WL23 0.00259f
C1231 BL4 a_327_7212# 0.0809f
C1232 BL4 a_531_4960# 0
C1233 a_21_3846# WL24 0
C1234 a_531_2316# WL15 0.00259f
C1235 BL6 a_735_7714# 0.0809f
C1236 a_429_1288# WL8 0.00259f
C1237 BL2 WL42 0.00428f
C1238 BL0 WL50 0.00508f
C1239 a_327_5070# WL32 0
C1240 a_633_9244# WL60 0.00259f
C1241 BL3 a_327_8326# 0.01064f
C1242 a_123_2206# a_123_2316# 0.07294f
C1243 BL3 WL31 0.00169f
C1244 a_429_2316# WL15 0.00259f
C1245 BL2 a_327_7102# 0.0809f
C1246 a_633_6600# WL43 0.00259f
C1247 a_633_2928# WL18 0
C1248 BL4 WL27 0.00417f
C1249 a_21_5988# WL38 0
C1250 a_531_5572# BL5 0.01064f
C1251 a_429_4960# a_531_4960# 0.08068f
C1252 a_531_7714# BL6 0.0809f
C1253 WL26 WL27 0.03692f
C1254 a_123_1594# BL2 0
C1255 BL0 WL28 0.00233f
C1256 BL3 a_327_6490# 0.01064f
C1257 a_21_2010# BL0 0.01064f
C1258 a_327_64# WL1 0
C1259 BL3 a_327_3234# 0.08359f
C1260 BL1 WL44 0.00158f
C1261 a_735_7824# BL7 0.01064f
C1262 a_225_480# WL3 0.00259f
C1263 a_327_1092# BL3 0.01064f
C1264 a_735_7824# WL51 0.00275f
C1265 BL6 a_735_480# 0.0809f
C1266 BL1 a_21_676# 0.0809f
C1267 a_21_3846# BL0 0.08359f
C1268 a_429_3540# WL23 0.00259f
C1269 a_531_8938# BL6 0.0809f
C1270 BL4 a_429_5878# 0.08359f
C1271 BL3 WL42 0.00158f
C1272 a_123_4042# BL1 0.08359f
C1273 a_327_4348# BL4 0.0809f
C1274 a_21_4764# WL30 0
C1275 a_735_3124# BL7 0.08359f
C1276 a_633_2010# BL6 0.01064f
C1277 BL3 a_327_7102# 0.01064f
C1278 a_531_370# BL4 0
C1279 a_633_4152# WL27 0.00259f
C1280 BL0 WL20 0.00497f
C1281 BL5 a_531_4458# 0.08359f
C1282 BL0 WL37 0.00508f
C1283 BL1 WL34 0.00417f
C1284 WL39 WL40 0.08922f
C1285 BL5 a_633_7212# 0.0809f
C1286 BL5 WL10 0.00158f
C1287 BL0 a_21_7102# 0.01064f
C1288 a_429_1594# a_429_1704# 0.07294f
C1289 a_633_8020# WL52 0.00259f
C1290 BL1 a_21_3430# 0.0809f
C1291 a_123_1594# a_225_1594# 0.08068f
C1292 BL1 WL47 0.00428f
C1293 a_429_4042# WL27 0
C1294 a_531_5572# WL36 0.00259f
C1295 WL13 WL14 0.08922f
C1296 BL2 WL10 0.00158f
C1297 a_531_3736# WL25 0
C1298 a_531_7824# WL51 0.00259f
C1299 BL5 WL29 0.00169f
C1300 BL1 a_123_2316# 0.01064f
C1301 BL5 a_429_3124# 0
C1302 a_327_174# WL0 0
C1303 a_429_7824# WL51 0.00259f
C1304 BL1 WL57 0.00158f
C1305 BL2 WL29 0.00169f
C1306 a_21_1900# WL12 0.00275f
C1307 a_327_7518# WL48 0
C1308 a_327_7518# BL4 0.0809f
C1309 a_225_7824# WL51 0.00259f
C1310 BL5 a_531_3124# 0.08359f
C1311 a_735_8632# WL57 0
C1312 a_531_8632# WL57 0
C1313 BL4 WL39 0.00417f
C1314 a_21_7518# WL48 0
C1315 BL2 a_225_4960# 0.08359f
C1316 a_735_9048# a_735_8938# 0.07294f
C1317 a_531_370# a_429_370# 0.08068f
C1318 a_531_8938# a_429_8938# 0.08068f
C1319 a_429_2206# BL4 0.01064f
C1320 a_633_7102# WL46 0.00259f
C1321 a_735_4654# WL31 0
C1322 BL2 a_225_5572# 0.01064f
C1323 BL4 a_429_6796# 0.01064f
C1324 BL0 a_21_6184# 0.08359f
C1325 BL3 WL10 0.00428f
C1326 WL35 WL34 0.03692f
C1327 BL5 a_633_8436# 0.0809f
C1328 a_225_1594# WL10 0.00259f
C1329 BL7 WL13 0.00508f
C1330 WL20 a_327_3234# 0
C1331 a_225_1398# WL8 0
C1332 WL2 WL3 0.03692f
C1333 a_735_5878# WL39 0
C1334 a_531_4654# WL31 0
C1335 BL3 WL29 0.00417f
C1336 a_21_64# BL1 0.0809f
C1337 a_225_6796# WL44 0.00259f
C1338 BL1 WL27 0.00417f
C1339 a_225_4960# a_123_4960# 0.08068f
C1340 BL5 WL4 0.00417f
C1341 a_531_7714# BL4 0
C1342 BL5 WL30 0.00169f
C1343 a_327_8020# WL52 0.00259f
C1344 BL3 a_429_3124# 0.0809f
C1345 a_633_6184# BL7 0.0809f
C1346 a_531_2316# a_429_2316# 0.08068f
C1347 a_531_1288# BL5 0.01064f
C1348 BL3 a_225_4960# 0.0809f
C1349 BL1 a_123_480# 0.01064f
C1350 BL2 WL4 0.00417f
C1351 BL2 WL30 0.00169f
C1352 BL6 a_531_2512# 0.0809f
C1353 a_21_2818# BL1 0.0809f
C1354 a_225_2206# WL14 0.00259f
C1355 a_531_8938# BL4 0
C1356 BL6 WL45 0.00428f
C1357 a_225_5682# BL1 0
C1358 a_735_4042# BL7 0.08359f
C1359 BL3 a_225_5572# 0.0809f
C1360 BL6 BL5 11.3838f
C1361 WL36 a_225_5572# 0.00259f
C1362 a_123_7824# WL51 0.00259f
C1363 a_123_1288# WL9 0
C1364 BL6 a_531_6796# 0.0809f
C1365 a_531_5572# WL37 0
C1366 a_225_2316# WL14 0
C1367 BL0 a_123_6796# 0.0809f
C1368 a_123_6906# WL45 0.00259f
C1369 a_429_7714# BL4 0.01064f
C1370 a_735_6906# WL44 0
C1371 WL28 a_531_4458# 0
C1372 a_123_370# WL2 0.00259f
C1373 a_123_3124# WL21 0
C1374 BL2 a_123_6906# 0
C1375 a_735_1704# WL11 0.00275f
C1376 BL6 a_735_5572# 0.0809f
C1377 a_225_2512# BL2 0.01064f
C1378 a_531_1704# a_429_1704# 0.08068f
C1379 a_633_8020# BL7 0.0809f
C1380 BL3 WL4 0.00169f
C1381 a_123_3540# WL22 0
C1382 WL23 WL22 0.03692f
C1383 BL3 WL30 0.00417f
C1384 a_123_1288# a_225_1288# 0.08068f
C1385 WL29 WL28 0.03692f
C1386 a_327_6490# a_327_6600# 0.07294f
C1387 a_531_5878# WL38 0.00259f
C1388 a_633_3430# WL23 0
C1389 BL7 WL46 0.00508f
C1390 a_225_3736# BL2 0.08359f
C1391 a_633_9244# BL7 0.0809f
C1392 BL5 a_531_480# 0.01064f
C1393 BL6 a_531_6906# 0.0809f
C1394 a_633_3846# BL5 0.0809f
C1395 a_225_786# BL2 0.08359f
C1396 a_21_7518# BL1 0.0809f
C1397 BL7 WL23 0.00233f
C1398 a_735_1288# WL8 0.00275f
C1399 WL42 a_327_6600# 0
C1400 BL1 WL39 0.00417f
C1401 BL6 WL36 0.00428f
C1402 a_123_8742# BL2 0
C1403 a_123_8632# WL56 0.00259f
C1404 BL5 a_429_8938# 0
C1405 BL7 WL2 0.00222f
C1406 BL7 WL19 0.00508f
C1407 a_225_2512# BL3 0.0809f
C1408 a_531_8742# BL5 0.01064f
C1409 BL7 WL60 0.00508f
C1410 a_531_3540# BL6 0.0809f
C1411 a_429_3124# WL20 0.00259f
C1412 BL5 WL5 0.00169f
C1413 a_429_3736# WL24 0.00259f
C1414 a_429_4654# WL31 0
C1415 BL5 WL40 0.00417f
C1416 a_327_6184# BL2 0.0809f
C1417 a_21_982# WL7 0
C1418 a_429_3540# WL22 0
C1419 BL6 WL49 0.00158f
C1420 a_225_3736# BL3 0.0809f
C1421 a_327_2010# BL2 0.0809f
C1422 WL20 a_531_3124# 0.00259f
C1423 BL2 WL5 0.00169f
C1424 a_123_4654# a_225_4654# 0.08068f
C1425 a_225_786# BL3 0.0809f
C1426 BL2 WL40 0.00417f
C1427 BL6 WL50 0.00428f
C1428 WL37 a_225_5572# 0
C1429 BL7 WL63 0.00222f
C1430 a_531_2622# WL17 0.00259f
C1431 WL52 a_21_8020# 0.00275f
C1432 BL4 a_531_2512# 0
C1433 BL6 a_531_9660# 0.0809f
C1434 a_429_8632# WL57 0
C1435 BL5 WL21 0.00417f
C1436 BL5 a_429_6294# 0
C1437 BL4 WL45 0.00158f
C1438 a_327_8436# BL2 0.0809f
C1439 a_633_2818# a_633_2928# 0.07294f
C1440 a_735_370# WL2 0.00275f
C1441 BL4 BL5 13.8033f
C1442 BL5 WL48 0.00428f
C1443 BL2 a_327_2928# 0.0809f
C1444 BL5 WL26 0.00169f
C1445 BL6 WL28 0.00169f
C1446 a_633_2010# a_633_1900# 0.07294f
C1447 a_123_370# WL3 0
C1448 BL2 WL21 0.00417f
C1449 a_225_1704# BL2 0.01064f
C1450 a_327_6184# BL3 0.08359f
C1451 BL4 a_531_6796# 0
C1452 a_123_5878# BL1 0.08359f
C1453 BL3 a_429_8938# 0.0809f
C1454 a_633_5070# WL32 0
C1455 WL17 WL18 0.08922f
C1456 a_21_7212# WL47 0.00275f
C1457 a_225_6906# WL45 0.00259f
C1458 BL2 WL48 0.00428f
C1459 a_327_2010# BL3 0.01064f
C1460 a_123_8632# a_225_8632# 0.08068f
C1461 BL2 WL26 0.00169f
C1462 a_735_8130# WL52 0
C1463 a_429_4960# BL5 0
C1464 BL3 WL5 0.00417f
C1465 a_633_1092# BL6 0.01064f
C1466 BL3 WL40 0.00169f
C1467 a_633_676# BL5 0.0809f
C1468 BL0 WL13 0.00222f
C1469 BL1 a_21_4764# 0.0809f
C1470 a_123_3124# BL1 0.08359f
C1471 a_429_2512# BL4 0.01064f
C1472 a_735_4654# WL30 0.00275f
C1473 BL2 a_225_6906# 0.01064f
C1474 a_123_1288# BL0 0.0809f
C1475 a_225_8938# BL2 0.01064f
C1476 BL6 WL20 0.00417f
C1477 BL7 WL52 0.00497f
C1478 BL6 WL37 0.00428f
C1479 a_531_4042# BL6 0.0809f
C1480 a_633_4152# BL5 0.0809f
C1481 BL1 a_21_6490# 0.0809f
C1482 a_327_8436# BL3 0.01064f
C1483 BL3 a_327_2928# 0.01064f
C1484 WL52 WL51 0.08922f
C1485 a_531_4654# WL30 0.00259f
C1486 a_531_8938# WL59 0
C1487 BL4 a_531_6906# 0
C1488 BL6 a_735_4654# 0.0809f
C1489 BL3 WL21 0.00169f
C1490 a_531_9048# a_531_8938# 0.07294f
C1491 a_225_1704# BL3 0.0809f
C1492 BL5 a_429_370# 0
C1493 a_429_4042# BL5 0
C1494 a_225_3540# BL2 0.08359f
C1495 a_225_1704# a_225_1594# 0.07294f
C1496 a_123_2206# BL2 0
C1497 a_123_7824# BL0 0.0809f
C1498 BL3 a_429_6294# 0.0809f
C1499 a_735_4458# WL28 0
C1500 BL4 WL36 0.00158f
C1501 BL7 WL3 0.00222f
C1502 WL9 a_531_1398# 0.00259f
C1503 BL3 BL4 11.3838f
C1504 a_531_8130# WL52 0
C1505 a_633_982# BL7 0.0809f
C1506 WL61 BL5 0.00428f
C1507 WL29 a_633_4348# 0
C1508 BL3 WL48 0.00158f
C1509 BL3 WL26 0.00417f
C1510 a_531_9550# WL63 0
C1511 a_633_7408# a_633_7518# 0.07294f
C1512 a_531_4654# BL6 0.0809f
C1513 a_21_1092# BL0 0.01064f
C1514 a_735_6796# BL6 0.0809f
C1515 a_225_9660# WL63 0.00259f
C1516 WL23 WL24 0.08922f
C1517 WL61 BL2 0.00428f
C1518 BL7 a_633_7102# 0.0809f
C1519 a_429_4960# BL3 0.0809f
C1520 BL3 a_225_6906# 0.0809f
C1521 a_531_3540# BL4 0
C1522 a_123_2316# WL15 0.00259f
C1523 a_225_8938# BL3 0.0809f
C1524 a_429_9660# BL4 0.01064f
C1525 a_531_5376# WL34 0
C1526 BL7 WL0 0.00508f
C1527 WL52 a_429_8130# 0
C1528 a_21_2928# WL18 0
C1529 BL5 WL6 0.00428f
C1530 BL4 WL49 0.00428f
C1531 WL48 WL49 0.03692f
C1532 a_225_8742# a_123_8742# 0.08068f
C1533 BL5 WL41 0.00169f
C1534 a_123_8938# BL2 0
C1535 BL4 WL50 0.00158f
C1536 a_225_3540# BL3 0.0809f
C1537 a_735_370# WL3 0
C1538 BL2 WL6 0.00428f
C1539 a_327_2818# WL19 0
C1540 BL0 WL46 0.00222f
C1541 BL7 WL56 0.00222f
C1542 BL2 WL41 0.00169f
C1543 a_735_5376# WL34 0
C1544 BL3 a_429_370# 0.0809f
C1545 a_429_4042# BL3 0.0809f
C1546 a_225_7714# BL1 0
C1547 WL16 a_531_2512# 0.00259f
C1548 a_123_3540# BL0 0.0809f
C1549 BL5 a_633_1900# 0.0809f
C1550 BL4 a_531_9660# 0
C1551 BL7 WL14 0.00222f
C1552 BL1 WL45 0.00158f
C1553 BL0 WL23 0.00497f
C1554 WL56 a_225_8632# 0.00259f
C1555 BL5 WL11 0.00158f
C1556 a_225_8130# WL52 0
C1557 BL5 WL16 0.00158f
C1558 BL3 WL61 0.00158f
C1559 WL10 a_429_1704# 0
C1560 BL4 WL28 0.00417f
C1561 a_633_5988# BL7 0.0809f
C1562 a_633_3430# WL22 0.00259f
C1563 BL1 BL2 13.8033f
C1564 BL2 WL11 0.00158f
C1565 a_531_8632# BL5 0.01064f
C1566 BL5 WL25 0.00417f
C1567 BL0 WL2 0.00508f
C1568 BL2 WL16 0.00158f
C1569 BL0 WL19 0.00222f
C1570 BL0 WL60 0.00222f
C1571 a_225_6294# WL40 0
C1572 BL1 a_123_7714# 0.01064f
C1573 BL1 a_123_9550# 0.01064f
C1574 BL1 a_123_1398# 0.01064f
C1575 BL6 a_633_4348# 0.08359f
C1576 a_429_2512# WL16 0.00259f
C1577 a_735_8130# BL7 0.08359f
C1578 BL7 WL22 0.00497f
C1579 BL3 WL6 0.00158f
C1580 a_429_480# a_531_480# 0.08068f
C1581 a_633_3430# BL7 0.0809f
C1582 BL2 WL25 0.00417f
C1583 WL52 a_123_8130# 0
C1584 BL3 WL41 0.00417f
C1585 a_123_9048# a_225_9048# 0.08068f
C1586 WL20 WL21 0.03692f
C1587 a_531_4042# BL4 0
C1588 BL4 WL20 0.00169f
C1589 a_429_4654# WL30 0.00259f
C1590 a_633_174# WL0 0
C1591 a_531_1594# a_429_1594# 0.08068f
C1592 BL7 a_633_6490# 0.0809f
C1593 BL4 WL37 0.00158f
C1594 BL7 a_633_5266# 0.0809f
C1595 a_327_9244# BL4 0.0809f
C1596 a_327_2010# a_327_1900# 0.07294f
C1597 a_531_4042# WL26 0.00259f
C1598 BL0 WL63 0.00508f
C1599 WL27 a_327_4152# 0.00259f
C1600 BL1 a_123_4960# 0.08359f
C1601 a_123_6796# a_123_6906# 0.07294f
C1602 BL7 WL58 0.00222f
C1603 a_633_2928# BL5 0.0809f
C1604 WL59 BL5 0.00158f
C1605 BL6 a_531_2206# 0.0809f
C1606 BL7 WL51 0.00222f
C1607 a_21_5988# WL39 0.00275f
C1608 BL3 WL11 0.00428f
C1609 a_531_9048# BL5 0.01064f
C1610 BL3 WL16 0.00428f
C1611 BL1 WL36 0.00158f
C1612 a_225_1594# WL11 0
C1613 BL5 WL62 0.00158f
C1614 a_123_9660# WL63 0.00259f
C1615 a_225_1594# BL1 0
C1616 WL40 a_21_6184# 0.00275f
C1617 BL5 WL35 0.00169f
C1618 WL59 BL2 0.00158f
C1619 WL54 BL7 0.00508f
C1620 BL0 a_123_8632# 0.0809f
C1621 a_735_7824# BL6 0.0809f
C1622 a_429_8742# a_531_8742# 0.08068f
C1623 a_531_4654# BL4 0
C1624 BL2 WL62 0.00158f
C1625 BL3 WL25 0.00169f
C1626 BL2 WL35 0.00169f
C1627 BL2 a_327_676# 0.0809f
C1628 BL7 WL9 0.00222f
C1629 a_327_7102# WL46 0.00259f
C1630 WL62 a_123_9550# 0.00259f
C1631 a_327_1900# BL4 0.0809f
C1632 BL4 a_429_6906# 0.01064f
C1633 a_633_6600# BL5 0.0809f
C1634 a_735_3124# BL6 0.0809f
C1635 a_327_3430# BL2 0.0809f
C1636 a_735_370# BL7 0.01064f
C1637 a_429_4042# a_531_4042# 0.08068f
C1638 BL1 WL49 0.00428f
C1639 a_327_9244# WL61 0
C1640 BL0 a_123_2622# 0.0809f
C1641 BL0 WL52 0.00233f
C1642 a_429_480# BL4 0.01064f
C1643 a_735_4960# WL32 0.00275f
C1644 a_21_4348# WL28 0.00275f
C1645 BL1 WL50 0.00158f
C1646 a_225_4458# WL29 0.00259f
C1647 a_735_2622# BL7 0.01064f
C1648 a_225_6796# WL45 0
C1649 a_531_7824# BL6 0.0809f
C1650 BL3 WL59 0.00428f
C1651 a_633_1092# WL6 0
C1652 a_21_6600# WL43 0.00275f
C1653 a_429_8742# BL4 0.01064f
C1654 a_429_2206# WL15 0
C1655 a_531_8130# a_429_8130# 0.08068f
C1656 BL0 WL3 0.00508f
C1657 BL4 a_327_6600# 0.0809f
C1658 BL3 WL62 0.00428f
C1659 BL7 a_633_174# 0.0809f
C1660 BL2 a_225_6796# 0.01064f
C1661 WL36 WL35 0.08922f
C1662 BL3 WL35 0.00417f
C1663 BL3 a_327_676# 0.08359f
C1664 a_429_5376# BL4 0.08359f
C1665 a_327_5070# BL2 0.0809f
C1666 BL1 WL28 0.00417f
C1667 a_21_2010# BL1 0.0809f
C1668 a_429_1398# BL5 0
C1669 BL7 WL33 0.00497f
C1670 a_327_3430# BL3 0.08359f
C1671 a_21_3846# BL1 0.0809f
C1672 a_531_5572# a_531_5682# 0.07294f
C1673 a_531_5572# a_429_5572# 0.08068f
C1674 a_327_5266# WL34 0.00259f
C1675 a_225_1288# WL9 0
C1676 a_429_9660# WL62 0
C1677 BL0 WL0 0.00222f
C1678 a_735_6906# WL45 0.00275f
C1679 a_225_6294# WL41 0.00259f
C1680 a_633_7212# WL46 0
C1681 a_429_480# a_429_370# 0.07294f
C1682 a_21_3846# WL25 0.00275f
C1683 BL1 WL37 0.00158f
C1684 BL1 WL20 0.00169f
C1685 a_225_8742# BL1 0
C1686 a_327_7518# a_327_7408# 0.07294f
C1687 a_429_9048# WL58 0
C1688 BL6 WL13 0.00158f
C1689 a_21_2818# a_21_2928# 0.07294f
C1690 a_531_1594# a_531_1704# 0.07294f
C1691 BL0 WL56 0.00508f
C1692 BL3 a_225_6796# 0.0809f
C1693 BL1 a_21_7102# 0.0809f
C1694 BL3 a_327_5070# 0.08359f
C1695 BL0 a_123_370# 0.0809f
C1696 BL0 WL14 0.00508f
C1697 BL1 a_225_6294# 0
C1698 BL4 a_531_2206# 0
C1699 a_531_9660# WL62 0
C1700 a_225_5878# BL1 0
C1701 BL0 a_21_8020# 0.08359f
C1702 BL4 a_429_4654# 0.08359f
C1703 BL7 WL24 0.00233f
C1704 a_531_5878# a_429_5878# 0.08068f
C1705 a_429_1398# BL3 0.0809f
C1706 a_429_8632# BL5 0
C1707 a_633_6184# BL6 0.08359f
C1708 WL41 a_21_6184# 0
C1709 a_735_4042# BL6 0.0809f
C1710 a_735_3124# WL21 0
C1711 BL2 a_327_64# 0.0809f
C1712 a_123_5572# BL2 0
C1713 a_633_8326# BL7 0.0809f
C1714 a_123_2512# BL2 0
C1715 BL0 WL22 0.00233f
C1716 BL4 a_429_1704# 0.01064f
C1717 BL1 a_21_6184# 0.0809f
C1718 BL0 WL58 0.00508f
C1719 a_225_5376# WL34 0
C1720 a_21_7518# a_21_7408# 0.07294f
C1721 a_633_8326# WL54 0.00259f
C1722 a_531_7824# BL4 0
C1723 BL0 WL51 0.00508f
C1724 BL5 WL8 0.00158f
C1725 a_633_8020# BL6 0.08359f
C1726 BL4 a_429_7824# 0.01064f
C1727 a_225_8130# a_123_8130# 0.08068f
C1728 a_327_2010# WL13 0.00259f
C1729 a_123_5682# a_225_5682# 0.08068f
C1730 BL0 WL54 0.00222f
C1731 a_531_5878# WL39 0
C1732 a_429_8632# BL3 0.0809f
C1733 BL6 WL46 0.00158f
C1734 BL3 a_327_64# 0.01064f
C1735 BL2 WL8 0.00158f
C1736 WL38 a_429_5878# 0.00259f
C1737 a_123_5572# WL36 0.00259f
C1738 a_633_9244# BL6 0.01064f
C1739 WL8 a_123_1398# 0
C1740 BL0 WL9 0.00508f
C1741 BL2 a_327_9354# 0.0809f
C1742 WL43 WL44 0.08922f
C1743 BL6 WL23 0.00417f
C1744 a_429_3736# BL4 0.08359f
C1745 a_429_2206# a_429_2316# 0.07294f
C1746 BL1 a_123_6796# 0.01064f
C1747 BL7 WL31 0.00497f
C1748 a_633_6184# WL40 0.00259f
C1749 a_327_1092# a_327_982# 0.07294f
C1750 BL6 WL2 0.00428f
C1751 a_633_7408# BL5 0.0809f
C1752 BL6 WL19 0.00158f
C1753 BL5 WL15 0.00158f
C1754 a_21_64# WL1 0
C1755 BL6 WL60 0.00158f
C1756 BL6 a_531_5682# 0.0809f
C1757 BL4 WL13 0.00428f
C1758 a_429_786# WL4 0
C1759 BL7 a_633_4764# 0.0809f
C1760 a_123_786# BL2 0
C1761 a_633_64# WL1 0
C1762 BL3 WL8 0.00428f
C1763 BL2 WL15 0.00158f
C1764 WL54 a_327_8326# 0.00259f
C1765 a_633_7212# a_633_7102# 0.07294f
C1766 BL3 a_327_9354# 0.01064f
C1767 a_21_2010# a_21_1900# 0.07294f
C1768 a_633_6490# WL42 0.00259f
C1769 BL6 WL63 0.00428f
C1770 a_429_5376# WL35 0.00259f
C1771 WL38 WL39 0.03692f
C1772 BL0 WL33 0.00233f
C1773 a_531_5376# BL5 0.08359f
C1774 BL7 WL42 0.00508f
C1775 a_531_4960# WL32 0.00259f
C1776 a_429_5682# BL4 0.01064f
C1777 WL55 BL5 0.00428f
C1778 a_531_480# WL2 0
C1779 BL2 a_327_4152# 0.0809f
C1780 a_735_4042# WL26 0.00275f
C1781 a_429_4458# a_531_4458# 0.08068f
C1782 a_327_174# BL4 0.0809f
C1783 BL2 WL55 0.00428f
C1784 WL17 a_531_2512# 0
C1785 WL53 BL5 0.00169f
C1786 a_735_9660# WL63 0.00275f
C1787 a_225_9660# a_123_9660# 0.08068f
C1788 a_531_1288# a_531_1398# 0.07294f
C1789 BL0 a_123_8130# 0.0809f
C1790 WL11 a_429_1704# 0.00259f
C1791 BL5 WL17 0.00158f
C1792 BL3 WL15 0.00428f
C1793 BL0 a_21_5266# 0.08359f
C1794 a_735_6796# a_735_6906# 0.07294f
C1795 WL53 BL2 0.00169f
C1796 a_429_4458# WL29 0.00259f
C1797 BL2 a_225_2622# 0.01064f
C1798 a_123_5572# WL37 0
C1799 a_123_5376# BL0 0.0809f
C1800 BL6 a_531_1398# 0.0809f
C1801 BL5 WL7 0.00428f
C1802 BL2 WL17 0.00158f
C1803 a_327_5988# BL4 0.0809f
C1804 WL4 WL3 0.08922f
C1805 BL6 WL52 0.00169f
C1806 a_429_2512# WL17 0
C1807 BL0 WL24 0.00497f
C1808 BL2 a_327_7408# 0.0809f
C1809 a_633_7408# WL49 0
C1810 a_225_7824# BL1 0
C1811 BL4 WL46 0.00428f
C1812 BL2 WL7 0.00428f
C1813 a_735_2316# WL14 0
C1814 BL3 a_327_4152# 0.08359f
C1815 BL0 a_21_4152# 0.08359f
C1816 BL3 WL55 0.00158f
C1817 BL2 a_225_4654# 0.08359f
C1818 a_531_1594# WL10 0.00259f
C1819 BL2 a_123_6294# 0
C1820 BL4 WL23 0.00169f
C1821 a_633_982# BL6 0.01064f
C1822 BL6 WL3 0.00428f
C1823 a_123_5878# WL38 0.00259f
C1824 a_225_6796# a_123_6796# 0.08068f
C1825 WL19 a_327_2928# 0.00259f
C1826 a_123_8742# a_123_8632# 0.07294f
C1827 BL7 WL10 0.00222f
C1828 WL53 BL3 0.00417f
C1829 a_429_786# WL5 0.00259f
C1830 BL3 a_225_2622# 0.0809f
C1831 BL7 a_633_7212# 0.0809f
C1832 BL6 a_633_7102# 0.01064f
C1833 BL3 WL17 0.00428f
C1834 BL4 WL2 0.00158f
C1835 a_21_7212# a_21_7102# 0.07294f
C1836 BL4 WL19 0.00428f
C1837 a_429_1594# WL10 0.00259f
C1838 BL2 a_123_1704# 0
C1839 WL13 a_633_1900# 0
C1840 BL4 WL60 0.00428f
C1841 a_327_9244# a_327_9354# 0.07294f
C1842 a_633_6184# WL41 0
C1843 a_429_3736# WL25 0
C1844 BL7 WL29 0.00233f
C1845 BL4 a_531_5682# 0
C1846 BL1 WL13 0.00428f
C1847 BL6 WL0 0.00158f
C1848 BL3 a_327_7408# 0.01064f
C1849 a_429_5572# BL4 0.01064f
C1850 a_633_5070# BL5 0.0809f
C1851 BL3 WL7 0.00158f
C1852 a_21_174# WL0 0
C1853 a_123_2206# a_225_2206# 0.08068f
C1854 a_123_1288# BL1 0.01064f
C1855 a_735_2316# BL7 0.01064f
C1856 a_225_3540# a_123_3540# 0.08068f
C1857 BL3 a_225_4654# 0.0809f
C1858 BL1 a_225_480# 0
C1859 a_225_3540# WL23 0.00259f
C1860 a_429_8742# a_429_8632# 0.07294f
C1861 WL9 WL10 0.08922f
C1862 a_123_9660# BL0 0.0809f
C1863 a_21_1092# WL6 0
C1864 BL4 WL63 0.00158f
C1865 a_531_2316# BL5 0.01064f
C1866 a_21_2818# WL18 0.00275f
C1867 BL1 a_225_4458# 0
C1868 a_531_5878# BL5 0.08359f
C1869 a_429_3540# BL4 0.08359f
C1870 BL6 WL56 0.00428f
C1871 BL4 a_429_786# 0.08359f
C1872 a_531_480# WL3 0.00259f
C1873 a_633_9244# WL61 0
C1874 BL4 a_327_8020# 0.0809f
C1875 a_735_1704# a_735_1594# 0.07294f
C1876 BL6 WL14 0.00428f
C1877 a_123_7824# BL1 0.01064f
C1878 WL49 a_327_7408# 0
C1879 a_429_2316# BL5 0
C1880 a_225_3124# WL21 0
C1881 a_21_8326# WL54 0.00275f
C1882 a_633_5988# BL6 0.08359f
C1883 a_327_3846# BL2 0.0809f
C1884 a_429_370# WL2 0.00259f
C1885 BL7 a_633_8436# 0.0809f
C1886 BL0 WL31 0.00233f
C1887 a_21_1092# BL1 0.0809f
C1888 BL4 a_429_2622# 0.01064f
C1889 WL61 WL60 0.03692f
C1890 BL7 WL4 0.00497f
C1891 BL7 WL30 0.00233f
C1892 a_225_4042# WL26 0.00259f
C1893 BL6 WL22 0.00169f
C1894 BL4 a_531_1398# 0
C1895 a_735_8130# BL6 0.0809f
C1896 a_21_5070# WL33 0.00275f
C1897 WL54 a_633_8436# 0
C1898 BL6 a_633_3430# 0.08359f
C1899 a_531_1594# BL6 0.0809f
C1900 a_429_1288# BL5 0
C1901 BL4 WL52 0.00417f
C1902 BL6 a_633_6490# 0.01064f
C1903 BL6 a_633_5266# 0.08359f
C1904 a_123_8742# WL56 0
C1905 BL1 WL46 0.00428f
C1906 BL6 BL7 11.3838f
C1907 a_123_4042# WL27 0
C1908 BL2 a_225_9550# 0.01064f
C1909 a_225_2206# BL1 0
C1910 BL6 WL58 0.00428f
C1911 BL5 WL38 0.00169f
C1912 a_735_1398# BL7 0.01064f
C1913 a_327_7212# WL47 0.00259f
C1914 BL0 WL42 0.00222f
C1915 a_633_1092# WL7 0.00259f
C1916 BL3 a_429_2316# 0.0809f
C1917 a_327_3846# BL3 0.08359f
C1918 BL2 a_123_4458# 0
C1919 BL6 WL51 0.00428f
C1920 a_123_3540# BL1 0.08359f
C1921 BL1 WL23 0.00169f
C1922 BL4 WL3 0.00158f
C1923 a_225_9550# a_123_9550# 0.08068f
C1924 a_633_2818# WL18 0.00259f
C1925 a_123_3736# BL2 0
C1926 a_225_4960# WL33 0
C1927 a_123_5682# BL2 0
C1928 a_21_7408# WL49 0
C1929 BL2 a_327_5266# 0.0809f
C1930 BL2 WL38 0.00169f
C1931 a_225_2316# BL1 0
C1932 a_531_1288# WL9 0
C1933 a_21_6490# a_21_6600# 0.07294f
C1934 a_531_8742# WL56 0
C1935 BL6 a_531_8130# 0.0809f
C1936 WL54 BL6 0.00158f
C1937 a_123_1594# BL0 0.0809f
C1938 a_429_9550# BL5 0
C1939 a_633_4764# WL31 0.00259f
C1940 BL1 WL2 0.00158f
C1941 BL1 WL19 0.00428f
C1942 BL1 WL60 0.00428f
C1943 BL6 WL9 0.00428f
C1944 a_735_9660# BL7 0.01064f
C1945 a_225_9048# BL2 0.01064f
C1946 a_633_2010# WL12 0
C1947 a_735_1398# WL9 0.00275f
C1948 BL4 WL0 0.00428f
C1949 WL10 a_531_1704# 0
C1950 a_735_370# BL6 0.0809f
C1951 BL3 a_225_9550# 0.0809f
C1952 BL3 a_429_1288# 0.0809f
C1953 a_633_9354# BL5 0.0809f
C1954 a_225_6294# a_123_6294# 0.08068f
C1955 BL7 a_735_4458# 0.08359f
C1956 a_633_3846# BL7 0.0809f
C1957 BL5 WL1 0.00428f
C1958 a_735_2622# BL6 0.0809f
C1959 a_123_5682# WL36 0
C1960 BL1 WL63 0.00158f
C1961 BL3 a_327_5266# 0.08359f
C1962 BL3 WL38 0.00417f
C1963 BL4 WL56 0.00158f
C1964 a_225_370# BL2 0.01064f
C1965 a_429_5376# a_531_5376# 0.08068f
C1966 BL4 a_429_4458# 0.08359f
C1967 a_429_370# WL3 0
C1968 WL0 VSS 0.33196f
C1969 WL1 VSS 0.24709f
C1970 WL2 VSS 0.24695f
C1971 WL3 VSS 0.2468f
C1972 WL4 VSS 0.24676f
C1973 WL5 VSS 0.2467f
C1974 WL6 VSS 0.24669f
C1975 WL7 VSS 0.24666f
C1976 WL8 VSS 0.24665f
C1977 WL9 VSS 0.24662f
C1978 WL10 VSS 0.2466f
C1979 WL11 VSS 0.2466f
C1980 WL12 VSS 0.2466f
C1981 WL13 VSS 0.2466f
C1982 WL14 VSS 0.2466f
C1983 WL15 VSS 0.2466f
C1984 WL16 VSS 0.2466f
C1985 WL17 VSS 0.2466f
C1986 WL18 VSS 0.2466f
C1987 WL19 VSS 0.2466f
C1988 WL20 VSS 0.2466f
C1989 WL21 VSS 0.2466f
C1990 WL22 VSS 0.2466f
C1991 WL23 VSS 0.2466f
C1992 WL24 VSS 0.2466f
C1993 WL25 VSS 0.2466f
C1994 WL26 VSS 0.2466f
C1995 WL27 VSS 0.2466f
C1996 WL28 VSS 0.2466f
C1997 WL29 VSS 0.2466f
C1998 WL30 VSS 0.2466f
C1999 WL31 VSS 0.2466f
C2000 WL32 VSS 0.2466f
C2001 WL33 VSS 0.2466f
C2002 WL34 VSS 0.2466f
C2003 WL35 VSS 0.2466f
C2004 WL36 VSS 0.2466f
C2005 WL37 VSS 0.2466f
C2006 WL38 VSS 0.2466f
C2007 WL39 VSS 0.2466f
C2008 WL40 VSS 0.2466f
C2009 WL41 VSS 0.2466f
C2010 WL42 VSS 0.2466f
C2011 WL43 VSS 0.2466f
C2012 WL44 VSS 0.2466f
C2013 WL45 VSS 0.2466f
C2014 WL46 VSS 0.2466f
C2015 WL47 VSS 0.2466f
C2016 WL48 VSS 0.2466f
C2017 WL49 VSS 0.2466f
C2018 WL50 VSS 0.2466f
C2019 WL51 VSS 0.2466f
C2020 WL52 VSS 0.2466f
C2021 WL53 VSS 0.2466f
C2022 WL54 VSS 0.2466f
C2023 WL55 VSS 0.24661f
C2024 WL56 VSS 0.24662f
C2025 WL57 VSS 0.24663f
C2026 WL58 VSS 0.24663f
C2027 WL59 VSS 0.24665f
C2028 WL60 VSS 0.24667f
C2029 BL7 VSS 5.28778f
C2030 BL5 VSS 2.95394f
C2031 BL4 VSS 2.95105f
C2032 BL2 VSS 2.95394f
C2033 BL1 VSS 2.96132f
C2034 WL61 VSS 0.24674f
C2035 WL62 VSS 0.24682f
C2036 BL6 VSS 3.2708f
C2037 BL3 VSS 3.26053f
C2038 BL0 VSS 5.55471f
C2039 WL63 VSS 0.33152f
C2040 a_633_64# VSS 0.07737f ; **FLOATING
C2041 a_327_64# VSS 0.07737f ; **FLOATING
C2042 a_21_64# VSS 0.09266f ; **FLOATING
C2043 a_633_174# VSS 0.07737f ; **FLOATING
C2044 a_327_174# VSS 0.07737f ; **FLOATING
C2045 a_21_174# VSS 0.09266f ; **FLOATING
C2046 a_735_370# VSS 0.09266f ; **FLOATING
C2047 a_531_370# VSS 0.07737f ; **FLOATING
C2048 a_429_370# VSS 0.07737f ; **FLOATING
C2049 a_225_370# VSS 0.07737f ; **FLOATING
C2050 a_123_370# VSS 0.07737f ; **FLOATING
C2051 a_735_480# VSS 0.09266f ; **FLOATING
C2052 a_531_480# VSS 0.07737f ; **FLOATING
C2053 a_429_480# VSS 0.07737f ; **FLOATING
C2054 a_225_480# VSS 0.07737f ; **FLOATING
C2055 a_123_480# VSS 0.07737f ; **FLOATING
C2056 a_633_676# VSS 0.07737f ; **FLOATING
C2057 a_327_676# VSS 0.07737f ; **FLOATING
C2058 a_21_676# VSS 0.09266f ; **FLOATING
C2059 a_735_786# VSS 0.09266f ; **FLOATING
C2060 a_531_786# VSS 0.07737f ; **FLOATING
C2061 a_429_786# VSS 0.07737f ; **FLOATING
C2062 a_225_786# VSS 0.07737f ; **FLOATING
C2063 a_123_786# VSS 0.07737f ; **FLOATING
C2064 a_633_982# VSS 0.07737f ; **FLOATING
C2065 a_327_982# VSS 0.07737f ; **FLOATING
C2066 a_21_982# VSS 0.09266f ; **FLOATING
C2067 a_633_1092# VSS 0.07737f ; **FLOATING
C2068 a_327_1092# VSS 0.07737f ; **FLOATING
C2069 a_21_1092# VSS 0.09266f ; **FLOATING
C2070 a_735_1288# VSS 0.09266f ; **FLOATING
C2071 a_531_1288# VSS 0.07737f ; **FLOATING
C2072 a_429_1288# VSS 0.07737f ; **FLOATING
C2073 a_225_1288# VSS 0.07737f ; **FLOATING
C2074 a_123_1288# VSS 0.07737f ; **FLOATING
C2075 a_735_1398# VSS 0.09266f ; **FLOATING
C2076 a_531_1398# VSS 0.07737f ; **FLOATING
C2077 a_429_1398# VSS 0.07737f ; **FLOATING
C2078 a_225_1398# VSS 0.07737f ; **FLOATING
C2079 a_123_1398# VSS 0.07737f ; **FLOATING
C2080 a_735_1594# VSS 0.09266f ; **FLOATING
C2081 a_531_1594# VSS 0.07737f ; **FLOATING
C2082 a_429_1594# VSS 0.07737f ; **FLOATING
C2083 a_225_1594# VSS 0.07737f ; **FLOATING
C2084 a_123_1594# VSS 0.07737f ; **FLOATING
C2085 a_735_1704# VSS 0.09266f ; **FLOATING
C2086 a_531_1704# VSS 0.07737f ; **FLOATING
C2087 a_429_1704# VSS 0.07737f ; **FLOATING
C2088 a_225_1704# VSS 0.07737f ; **FLOATING
C2089 a_123_1704# VSS 0.07737f ; **FLOATING
C2090 a_633_1900# VSS 0.07737f ; **FLOATING
C2091 a_327_1900# VSS 0.07737f ; **FLOATING
C2092 a_21_1900# VSS 0.09266f ; **FLOATING
C2093 a_633_2010# VSS 0.07737f ; **FLOATING
C2094 a_327_2010# VSS 0.07737f ; **FLOATING
C2095 a_21_2010# VSS 0.09266f ; **FLOATING
C2096 a_735_2206# VSS 0.09266f ; **FLOATING
C2097 a_531_2206# VSS 0.07737f ; **FLOATING
C2098 a_429_2206# VSS 0.07737f ; **FLOATING
C2099 a_225_2206# VSS 0.07737f ; **FLOATING
C2100 a_123_2206# VSS 0.07737f ; **FLOATING
C2101 a_735_2316# VSS 0.09266f ; **FLOATING
C2102 a_531_2316# VSS 0.07737f ; **FLOATING
C2103 a_429_2316# VSS 0.07737f ; **FLOATING
C2104 a_225_2316# VSS 0.07737f ; **FLOATING
C2105 a_123_2316# VSS 0.07737f ; **FLOATING
C2106 a_735_2512# VSS 0.09266f ; **FLOATING
C2107 a_531_2512# VSS 0.07737f ; **FLOATING
C2108 a_429_2512# VSS 0.07737f ; **FLOATING
C2109 a_225_2512# VSS 0.07737f ; **FLOATING
C2110 a_123_2512# VSS 0.07737f ; **FLOATING
C2111 a_735_2622# VSS 0.09266f ; **FLOATING
C2112 a_531_2622# VSS 0.07737f ; **FLOATING
C2113 a_429_2622# VSS 0.07737f ; **FLOATING
C2114 a_225_2622# VSS 0.07737f ; **FLOATING
C2115 a_123_2622# VSS 0.07737f ; **FLOATING
C2116 a_633_2818# VSS 0.07737f ; **FLOATING
C2117 a_327_2818# VSS 0.07737f ; **FLOATING
C2118 a_21_2818# VSS 0.09266f ; **FLOATING
C2119 a_633_2928# VSS 0.07737f ; **FLOATING
C2120 a_327_2928# VSS 0.07737f ; **FLOATING
C2121 a_21_2928# VSS 0.09266f ; **FLOATING
C2122 a_735_3124# VSS 0.09266f ; **FLOATING
C2123 a_531_3124# VSS 0.07737f ; **FLOATING
C2124 a_429_3124# VSS 0.07737f ; **FLOATING
C2125 a_225_3124# VSS 0.07737f ; **FLOATING
C2126 a_123_3124# VSS 0.07737f ; **FLOATING
C2127 a_633_3234# VSS 0.07737f ; **FLOATING
C2128 a_327_3234# VSS 0.07737f ; **FLOATING
C2129 a_21_3234# VSS 0.09266f ; **FLOATING
C2130 a_633_3430# VSS 0.07737f ; **FLOATING
C2131 a_327_3430# VSS 0.07737f ; **FLOATING
C2132 a_21_3430# VSS 0.09266f ; **FLOATING
C2133 a_735_3540# VSS 0.09266f ; **FLOATING
C2134 a_531_3540# VSS 0.07737f ; **FLOATING
C2135 a_429_3540# VSS 0.07737f ; **FLOATING
C2136 a_225_3540# VSS 0.07737f ; **FLOATING
C2137 a_123_3540# VSS 0.07737f ; **FLOATING
C2138 a_735_3736# VSS 0.09266f ; **FLOATING
C2139 a_531_3736# VSS 0.07737f ; **FLOATING
C2140 a_429_3736# VSS 0.07737f ; **FLOATING
C2141 a_225_3736# VSS 0.07737f ; **FLOATING
C2142 a_123_3736# VSS 0.07737f ; **FLOATING
C2143 a_633_3846# VSS 0.07737f ; **FLOATING
C2144 a_327_3846# VSS 0.07737f ; **FLOATING
C2145 a_21_3846# VSS 0.09266f ; **FLOATING
C2146 a_735_4042# VSS 0.09266f ; **FLOATING
C2147 a_531_4042# VSS 0.07737f ; **FLOATING
C2148 a_429_4042# VSS 0.07737f ; **FLOATING
C2149 a_225_4042# VSS 0.07737f ; **FLOATING
C2150 a_123_4042# VSS 0.07737f ; **FLOATING
C2151 a_633_4152# VSS 0.07737f ; **FLOATING
C2152 a_327_4152# VSS 0.07737f ; **FLOATING
C2153 a_21_4152# VSS 0.09266f ; **FLOATING
C2154 a_633_4348# VSS 0.07737f ; **FLOATING
C2155 a_327_4348# VSS 0.07737f ; **FLOATING
C2156 a_21_4348# VSS 0.09266f ; **FLOATING
C2157 a_735_4458# VSS 0.09266f ; **FLOATING
C2158 a_531_4458# VSS 0.07737f ; **FLOATING
C2159 a_429_4458# VSS 0.07737f ; **FLOATING
C2160 a_225_4458# VSS 0.07737f ; **FLOATING
C2161 a_123_4458# VSS 0.07737f ; **FLOATING
C2162 a_735_4654# VSS 0.09266f ; **FLOATING
C2163 a_531_4654# VSS 0.07737f ; **FLOATING
C2164 a_429_4654# VSS 0.07737f ; **FLOATING
C2165 a_225_4654# VSS 0.07737f ; **FLOATING
C2166 a_123_4654# VSS 0.07737f ; **FLOATING
C2167 a_633_4764# VSS 0.07737f ; **FLOATING
C2168 a_327_4764# VSS 0.07737f ; **FLOATING
C2169 a_21_4764# VSS 0.09266f ; **FLOATING
C2170 a_735_4960# VSS 0.09266f ; **FLOATING
C2171 a_531_4960# VSS 0.07737f ; **FLOATING
C2172 a_429_4960# VSS 0.07737f ; **FLOATING
C2173 a_225_4960# VSS 0.07737f ; **FLOATING
C2174 a_123_4960# VSS 0.07737f ; **FLOATING
C2175 a_633_5070# VSS 0.07737f ; **FLOATING
C2176 a_327_5070# VSS 0.07737f ; **FLOATING
C2177 a_21_5070# VSS 0.09266f ; **FLOATING
C2178 a_633_5266# VSS 0.07737f ; **FLOATING
C2179 a_327_5266# VSS 0.07737f ; **FLOATING
C2180 a_21_5266# VSS 0.09266f ; **FLOATING
C2181 a_735_5376# VSS 0.09266f ; **FLOATING
C2182 a_531_5376# VSS 0.07737f ; **FLOATING
C2183 a_429_5376# VSS 0.07737f ; **FLOATING
C2184 a_225_5376# VSS 0.07737f ; **FLOATING
C2185 a_123_5376# VSS 0.07737f ; **FLOATING
C2186 a_735_5572# VSS 0.09266f ; **FLOATING
C2187 a_531_5572# VSS 0.07737f ; **FLOATING
C2188 a_429_5572# VSS 0.07737f ; **FLOATING
C2189 a_225_5572# VSS 0.07737f ; **FLOATING
C2190 a_123_5572# VSS 0.07737f ; **FLOATING
C2191 a_735_5682# VSS 0.09266f ; **FLOATING
C2192 a_531_5682# VSS 0.07737f ; **FLOATING
C2193 a_429_5682# VSS 0.07737f ; **FLOATING
C2194 a_225_5682# VSS 0.07737f ; **FLOATING
C2195 a_123_5682# VSS 0.07737f ; **FLOATING
C2196 a_735_5878# VSS 0.09266f ; **FLOATING
C2197 a_531_5878# VSS 0.07737f ; **FLOATING
C2198 a_429_5878# VSS 0.07737f ; **FLOATING
C2199 a_225_5878# VSS 0.07737f ; **FLOATING
C2200 a_123_5878# VSS 0.07737f ; **FLOATING
C2201 a_633_5988# VSS 0.07737f ; **FLOATING
C2202 a_327_5988# VSS 0.07737f ; **FLOATING
C2203 a_21_5988# VSS 0.09266f ; **FLOATING
C2204 a_633_6184# VSS 0.07737f ; **FLOATING
C2205 a_327_6184# VSS 0.07737f ; **FLOATING
C2206 a_21_6184# VSS 0.09266f ; **FLOATING
C2207 a_735_6294# VSS 0.09266f ; **FLOATING
C2208 a_531_6294# VSS 0.07737f ; **FLOATING
C2209 a_429_6294# VSS 0.07737f ; **FLOATING
C2210 a_225_6294# VSS 0.07737f ; **FLOATING
C2211 a_123_6294# VSS 0.07737f ; **FLOATING
C2212 a_633_6490# VSS 0.07737f ; **FLOATING
C2213 a_327_6490# VSS 0.07737f ; **FLOATING
C2214 a_21_6490# VSS 0.09266f ; **FLOATING
C2215 a_633_6600# VSS 0.07737f ; **FLOATING
C2216 a_327_6600# VSS 0.07737f ; **FLOATING
C2217 a_21_6600# VSS 0.09266f ; **FLOATING
C2218 a_735_6796# VSS 0.09266f ; **FLOATING
C2219 a_531_6796# VSS 0.07737f ; **FLOATING
C2220 a_429_6796# VSS 0.07737f ; **FLOATING
C2221 a_225_6796# VSS 0.07737f ; **FLOATING
C2222 a_123_6796# VSS 0.07737f ; **FLOATING
C2223 a_735_6906# VSS 0.09266f ; **FLOATING
C2224 a_531_6906# VSS 0.07737f ; **FLOATING
C2225 a_429_6906# VSS 0.07737f ; **FLOATING
C2226 a_225_6906# VSS 0.07737f ; **FLOATING
C2227 a_123_6906# VSS 0.07737f ; **FLOATING
C2228 a_633_7102# VSS 0.07737f ; **FLOATING
C2229 a_327_7102# VSS 0.07737f ; **FLOATING
C2230 a_21_7102# VSS 0.09266f ; **FLOATING
C2231 a_633_7212# VSS 0.07737f ; **FLOATING
C2232 a_327_7212# VSS 0.07737f ; **FLOATING
C2233 a_21_7212# VSS 0.09266f ; **FLOATING
C2234 a_633_7408# VSS 0.07737f ; **FLOATING
C2235 a_327_7408# VSS 0.07737f ; **FLOATING
C2236 a_21_7408# VSS 0.09266f ; **FLOATING
C2237 a_633_7518# VSS 0.07737f ; **FLOATING
C2238 a_327_7518# VSS 0.07737f ; **FLOATING
C2239 a_21_7518# VSS 0.09266f ; **FLOATING
C2240 a_735_7714# VSS 0.09266f ; **FLOATING
C2241 a_531_7714# VSS 0.07737f ; **FLOATING
C2242 a_429_7714# VSS 0.07737f ; **FLOATING
C2243 a_225_7714# VSS 0.07737f ; **FLOATING
C2244 a_123_7714# VSS 0.07737f ; **FLOATING
C2245 a_735_7824# VSS 0.09266f ; **FLOATING
C2246 a_531_7824# VSS 0.07737f ; **FLOATING
C2247 a_429_7824# VSS 0.07737f ; **FLOATING
C2248 a_225_7824# VSS 0.07737f ; **FLOATING
C2249 a_123_7824# VSS 0.07737f ; **FLOATING
C2250 a_633_8020# VSS 0.07737f ; **FLOATING
C2251 a_327_8020# VSS 0.07737f ; **FLOATING
C2252 a_21_8020# VSS 0.09266f ; **FLOATING
C2253 a_735_8130# VSS 0.09266f ; **FLOATING
C2254 a_531_8130# VSS 0.07737f ; **FLOATING
C2255 a_429_8130# VSS 0.07737f ; **FLOATING
C2256 a_225_8130# VSS 0.07737f ; **FLOATING
C2257 a_123_8130# VSS 0.07737f ; **FLOATING
C2258 a_633_8326# VSS 0.07737f ; **FLOATING
C2259 a_327_8326# VSS 0.07737f ; **FLOATING
C2260 a_21_8326# VSS 0.09266f ; **FLOATING
C2261 a_633_8436# VSS 0.07737f ; **FLOATING
C2262 a_327_8436# VSS 0.07737f ; **FLOATING
C2263 a_21_8436# VSS 0.09266f ; **FLOATING
C2264 a_735_8632# VSS 0.09266f ; **FLOATING
C2265 a_531_8632# VSS 0.07737f ; **FLOATING
C2266 a_429_8632# VSS 0.07737f ; **FLOATING
C2267 a_225_8632# VSS 0.07737f ; **FLOATING
C2268 a_123_8632# VSS 0.07737f ; **FLOATING
C2269 a_735_8742# VSS 0.09266f ; **FLOATING
C2270 a_531_8742# VSS 0.07737f ; **FLOATING
C2271 a_429_8742# VSS 0.07737f ; **FLOATING
C2272 a_225_8742# VSS 0.07737f ; **FLOATING
C2273 a_123_8742# VSS 0.07737f ; **FLOATING
C2274 a_735_8938# VSS 0.09266f ; **FLOATING
C2275 a_531_8938# VSS 0.07737f ; **FLOATING
C2276 a_429_8938# VSS 0.07737f ; **FLOATING
C2277 a_225_8938# VSS 0.07737f ; **FLOATING
C2278 a_123_8938# VSS 0.07737f ; **FLOATING
C2279 a_735_9048# VSS 0.09266f ; **FLOATING
C2280 a_531_9048# VSS 0.07737f ; **FLOATING
C2281 a_429_9048# VSS 0.07737f ; **FLOATING
C2282 a_225_9048# VSS 0.07737f ; **FLOATING
C2283 a_123_9048# VSS 0.07737f ; **FLOATING
C2284 a_633_9244# VSS 0.07737f ; **FLOATING
C2285 a_327_9244# VSS 0.07737f ; **FLOATING
C2286 a_21_9244# VSS 0.09266f ; **FLOATING
C2287 a_633_9354# VSS 0.07737f ; **FLOATING
C2288 a_327_9354# VSS 0.07737f ; **FLOATING
C2289 a_21_9354# VSS 0.09266f ; **FLOATING
C2290 a_735_9550# VSS 0.09266f ; **FLOATING
C2291 a_531_9550# VSS 0.07737f ; **FLOATING
C2292 a_429_9550# VSS 0.07737f ; **FLOATING
C2293 a_225_9550# VSS 0.07737f ; **FLOATING
C2294 a_123_9550# VSS 0.07737f ; **FLOATING
C2295 a_735_9660# VSS 0.09266f ; **FLOATING
C2296 a_531_9660# VSS 0.07737f ; **FLOATING
C2297 a_429_9660# VSS 0.07737f ; **FLOATING
C2298 a_225_9660# VSS 0.07737f ; **FLOATING
C2299 a_123_9660# VSS 0.07737f ; **FLOATING
.ends
