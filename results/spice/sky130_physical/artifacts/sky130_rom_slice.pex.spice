* NGSPICE file created from sky130_rom_slice.ext - technology: sky130A

.subckt sky130_rom_slice VGND VPWR WL_PRESENT EN_PRESENT PRE_PRESENT Q_PRESENT WL_ABSENT
+ EN_ABSENT PRE_ABSENT Q_ABSENT
X0 VGND EN_ABSENT NROW_ABSENT/S VGND sky130_fd_pr__nfet_01v8 ad=0.29 pd=2.58 as=0.29 ps=2.58 w=1 l=0.15
X1 VPWR PRE_ABSENT BL_ABSENT VPWR sky130_fd_pr__pfet_01v8 ad=0.29 pd=2.58 as=0.29 ps=2.58 w=1 l=0.15
X2 VPWR BL_PRESENT Q_PRESENT VPWR sky130_fd_pr__pfet_01v8 ad=1.16 pd=10.32 as=0.29 ps=2.58 w=1 l=0.15
X3 VPWR PRE_PRESENT BL_PRESENT VPWR sky130_fd_pr__pfet_01v8 ad=0 pd=0 as=0.29 ps=2.58 w=1 l=0.15
X4 NROW_PRESENT/S WL_PRESENT BL_PRESENT VGND sky130_fd_pr__nfet_01v8 ad=0.58 pd=5.16 as=0.29 ps=2.58 w=1 l=0.15
X5 VPWR BL_ABSENT Q_ABSENT VPWR sky130_fd_pr__pfet_01v8 ad=0 pd=0 as=0.29 ps=2.58 w=1 l=0.15
X6 VGND BL_PRESENT Q_PRESENT VGND sky130_fd_pr__nfet_01v8 ad=1.16 pd=10.32 as=0.29 ps=2.58 w=1 l=0.15
X7 VGND BL_ABSENT Q_ABSENT VGND sky130_fd_pr__nfet_01v8 ad=0 pd=0 as=0.29 ps=2.58 w=1 l=0.15
X8 VGND EN_PRESENT NROW_PRESENT/S VGND sky130_fd_pr__nfet_01v8 ad=0 pd=0 as=0 ps=0 w=1 l=0.15
X9 NROW_ABSENT/S WL_ABSENT ROM_DRAIN_ABSENT VGND sky130_fd_pr__nfet_01v8 ad=0.58 pd=5.16 as=0.29 ps=2.58 w=1 l=0.15
C0 VPWR NROW_PRESENT/S 0.03401f
C1 WL_ABSENT VPWR 0.0273f
C2 EN_ABSENT VPWR 0.01801f
C3 WL_ABSENT EN_ABSENT 0.00718f
C4 VPWR WL_PRESENT 0.0273f
C5 WL_PRESENT NROW_PRESENT/S 0.02351f
C6 ROM_DRAIN_ABSENT Q_ABSENT 0
C7 Q_PRESENT PRE_PRESENT 0
C8 NROW_ABSENT/S Q_ABSENT 0.0033f
C9 EN_PRESENT Q_PRESENT 0.00117f
C10 Q_PRESENT BL_PRESENT 0.20138f
C11 VPWR PRE_ABSENT 0.30094f
C12 WL_ABSENT PRE_ABSENT 0.00107f
C13 Q_ABSENT VPWR 0.42598f
C14 WL_ABSENT Q_ABSENT 0
C15 VPWR PRE_PRESENT 0.3007f
C16 EN_ABSENT Q_ABSENT 0.00117f
C17 EN_PRESENT VPWR 0.01801f
C18 EN_PRESENT NROW_PRESENT/S 0.0241f
C19 VPWR BL_PRESENT 0.7599f
C20 BL_PRESENT NROW_PRESENT/S 0.26118f
C21 WL_ABSENT BL_PRESENT 0.00149f
C22 ROM_DRAIN_ABSENT BL_ABSENT 0.03771f
C23 PRE_PRESENT WL_PRESENT 0.00107f
C24 EN_PRESENT WL_PRESENT 0.00718f
C25 NROW_ABSENT/S BL_ABSENT 0.08909f
C26 WL_PRESENT BL_PRESENT 0.13617f
C27 Q_ABSENT PRE_ABSENT 0
C28 VPWR BL_ABSENT 0.76139f
C29 WL_ABSENT BL_ABSENT 0.08709f
C30 PRE_ABSENT BL_PRESENT 0.00154f
C31 EN_ABSENT BL_ABSENT 0.11043f
C32 PRE_PRESENT BL_PRESENT 0.12679f
C33 NROW_ABSENT/S ROM_DRAIN_ABSENT 0.16971f
C34 EN_PRESENT BL_PRESENT 0.11043f
C35 BL_ABSENT PRE_ABSENT 0.12679f
C36 Q_PRESENT VPWR 0.42818f
C37 Q_PRESENT NROW_PRESENT/S 0.0033f
C38 WL_ABSENT Q_PRESENT 0
C39 WL_ABSENT ROM_DRAIN_ABSENT 0.04438f
C40 Q_ABSENT BL_ABSENT 0.20136f
C41 NROW_ABSENT/S VPWR 0.03401f
C42 WL_ABSENT NROW_ABSENT/S 0.02371f
C43 Q_PRESENT WL_PRESENT 0
C44 NROW_ABSENT/S EN_ABSENT 0.0241f
C45 NROW_ABSENT/S VGND 0.76272f
C46 ROM_DRAIN_ABSENT VGND 0.14344f
C47 WL_ABSENT VGND 0.41249f
C48 EN_PRESENT VGND 0.38823f
C49 Q_ABSENT VGND 1.00076f
C50 Q_PRESENT VGND 0.99782f
C51 NROW_PRESENT/S VGND 0.76272f
C52 BL_PRESENT VGND 2.09652f
C53 WL_PRESENT VGND 0.41204f
C54 VPWR VGND 6.16899f
C55 PRE_PRESENT VGND 0.17687f
C56 BL_ABSENT VGND 1.95095f
C57 PRE_ABSENT VGND 0.17492f
C58 EN_ABSENT VGND 0.38823f
.ends
